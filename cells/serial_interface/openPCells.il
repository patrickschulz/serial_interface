let(
    (
        (cv geGetEditCellView())
        shape
    )
    shape = dbCreateRect(cv list("M2" "drawing") list(-0.010:0.060 0.010:0.100))
    shape = dbCreateRect(cv list("M1" "drawing") list(-0.010:0.060 0.010:0.100))
    shape = dbCreateRect(cv list("M2" "drawing") list(0.104:-0.020 0.252:0.020))
    shape = dbCreateRect(cv list("M1" "drawing") list(0.104:-0.020 0.252:0.020))
    shape = dbCreateRect(cv list("M2" "drawing") list(0.198:-0.180 0.322:-0.140))
    shape = dbCreateRect(cv list("M1" "drawing") list(0.198:-0.180 0.322:-0.140))
    shape = dbCreateRect(cv list("V1" "drawing") list(0.220:-0.180 0.300:-0.140))
    shape = dbCreateRect(cv list("V1" "drawing") list(0.138:-0.020 0.218:0.020))
    shape = dbCreateRect(cv list("V1" "drawing") list(0.629:-0.100 0.709:-0.060))
    shape = dbCreateRect(cv list("V1" "drawing") list(0.435:-0.100 0.515:-0.060))
    shape = dbCreateRect(cv list("V1" "drawing") list(1.572:-0.020 1.652:0.020))
    shape = dbCreateRect(cv list("V1" "drawing") list(1.624:-0.100 1.704:-0.060))
    shape = dbCreateRect(cv list("V1" "drawing") list(0.948:0.060 1.028:0.100))
    shape = dbCreateRect(cv list("V1" "drawing") list(0.948:-0.100 1.028:-0.060))
    shape = dbCreateRect(cv list("V1" "drawing") list(1.260:0.060 1.340:0.100))
    shape = dbCreateRect(cv list("V1" "drawing") list(1.260:-0.100 1.340:-0.060))
    shape = dbCreateRect(cv list("V1" "drawing") list(0.629:0.060 0.709:0.100))
    shape = dbCreateRect(cv list("V1" "drawing") list(0.435:0.060 0.515:0.100))
    shape = dbCreateRect(cv list("V1" "drawing") list(-0.040:0.060 0.040:0.100))
    shape = dbCreateRect(cv list("M1" "drawing") list(1.840:-0.020 1.976:0.020))
    shape = dbCreateRect(cv list("M2" "drawing") list(0.000:0.060 0.668:0.100))
    shape = dbCreateRect(cv list("M1" "drawing") list(0.372:0.060 0.772:0.100))
    shape = dbCreateRect(cv list("M1" "drawing") list(1.204:-0.100 1.396:-0.060))
    shape = dbCreateRect(cv list("M1" "drawing") list(1.204:0.060 1.396:0.100))
    shape = dbCreateRect(cv list("M1" "drawing") list(0.892:-0.100 1.084:-0.060))
    shape = dbCreateRect(cv list("M1" "drawing") list(0.892:0.060 1.084:0.100))
    shape = dbCreateRect(cv list("M1" "drawing") list(1.560:-0.100 1.768:-0.060))
    shape = dbCreatePolygon(cv list("M1" "drawing") list(1.684:0.000 1.684:0.060 1.768:0.060 1.768:0.100 1.644:0.100 1.644:0.000))
    shape = dbCreateRect(cv list("M1" "drawing") list(1.528:-0.020 1.696:0.020))
    shape = dbCreateRect(cv list("M1" "drawing") list(0.372:-0.100 0.772:-0.060))
    shape = dbCreateRect(cv list("M1" "drawing") list(0.312:-0.020 0.772:0.020))
    shape = dbCreatePolygon(cv list("M2" "drawing") list(0.104:-0.020 0.292:-0.020 0.292:-0.100 0.852:-0.100 0.852:0.060 1.748:0.060 1.748:-0.060 1.560:-0.060 1.560:-0.100 1.788:-0.100 1.788:0.100 0.812:0.100 0.812:-0.060 0.332:-0.060 0.332:0.020 0.104:0.020))
    shape = dbCreatePolygon(cv list("M2" "drawing") list(0.260:-0.180 0.956:-0.180 0.956:-0.100 1.476:-0.100 1.476:-0.020 1.664:-0.020 1.664:0.020 1.436:0.020 1.436:-0.060 0.916:-0.060 0.916:-0.140 0.260:-0.140))
    shape = dbCreateRect(cv list("M1" "drawing") list(1.456:0.060 1.614:0.100))
    shape = dbCreatePolygon(cv list("M1" "drawing") list(1.612:-0.340 1.840:-0.340 1.840:-0.180 1.892:-0.180 1.892:0.000 1.852:0.000 1.852:-0.140 1.800:-0.140 1.800:-0.300 1.612:-0.300))
    shape = dbCreatePolygon(cv list("M1" "drawing") list(1.612:0.300 1.800:0.300 1.800:0.140 1.852:0.140 1.852:0.000 1.892:0.000 1.892:0.180 1.840:0.180 1.840:0.340 1.612:0.340))
    shape = dbCreatePolygon(cv list("M1" "drawing") list(0.884:-0.310 1.112:-0.310 1.112:-0.180 1.164:-0.180 1.164:0.000 1.124:0.000 1.124:-0.140 1.072:-0.140 1.072:-0.270 0.884:-0.270))
    shape = dbCreatePolygon(cv list("M1" "drawing") list(0.884:0.270 1.072:0.270 1.072:0.140 1.124:0.140 1.124:0.000 1.164:0.000 1.164:0.180 1.112:0.180 1.112:0.310 0.884:0.310))
    shape = dbCreateRect(cv list("M1" "drawing") list(2.080:-0.020 2.184:0.020))
    shape = dbCreateRect(cv list("CA" "drawing") list(2.221:-0.220 2.251:-0.160))
    shape = dbCreateRect(cv list("CA" "drawing") list(2.221:0.160 2.251:0.220))
    shape = dbCreateRect(cv list("M1" "drawing") list(2.112:-0.400 2.152:-0.340))
    shape = dbCreateRect(cv list("CA" "drawing") list(2.117:-0.320 2.147:-0.260))
    shape = dbCreateRect(cv list("M1" "drawing") list(2.112:0.340 2.152:0.400))
    shape = dbCreateRect(cv list("CA" "drawing") list(2.117:0.260 2.147:0.320))
    shape = dbCreateRect(cv list("CB" "drawing") list(2.164:-0.020 2.204:0.020))
    shape = dbCreateRect(cv list("M1" "drawing") list(2.112:-0.520 2.256:-0.400))
    shape = dbCreateRect(cv list("M1" "drawing") list(2.112:0.400 2.256:0.520))
    shape = dbCreateRect(cv list("PC" "drawing") list(2.174:-0.542 2.194:0.000))
    shape = dbCreateRect(cv list("RX" "drawing") list(2.082:-0.340 2.286:-0.140))
    shape = dbCreateRect(cv list("NPLUS" "drawing") list(1.982:-0.642 2.386:0.000))
    shape = dbCreateRect(cv list("NW" "drawing") list(1.982:-0.642 2.386:0.000))
    shape = dbCreateRect(cv list("LVTN" "drawing") list(1.982:-0.642 2.386:0.000))
    shape = dbCreateRect(cv list("CT" "drawing") list(2.132:-0.492 2.236:-0.428))
    shape = dbCreateRect(cv list("PC" "drawing") list(2.174:0.000 2.194:0.542))
    shape = dbCreateRect(cv list("RX" "drawing") list(2.082:0.140 2.286:0.340))
    shape = dbCreateRect(cv list("PPLUS" "drawing") list(1.982:0.000 2.386:0.642))
    shape = dbCreateRect(cv list("NW" "drawing") list(1.982:0.000 2.386:0.642))
    shape = dbCreateRect(cv list("RVTP" "drawing") list(1.982:0.000 2.386:0.642))
    shape = dbCreateRect(cv list("CT" "drawing") list(2.132:0.428 2.236:0.492))
    shape = dbCreatePolygon(cv list("M1" "drawing") list(2.236:0.140 2.268:0.140 2.268:-0.140 2.236:-0.140 2.236:-0.180 2.308:-0.180 2.308:0.180 2.236:0.180))
    shape = dbCreateRect(cv list("M1" "drawing") list(2.174:-0.020 2.194:0.020))
    shape = dbCreateRect(cv list("M1" "drawing") list(2.112:0.240 2.152:0.340))
    shape = dbCreateRect(cv list("M1" "drawing") list(2.112:-0.340 2.152:-0.240))
    shape = dbCreateRect(cv list("M1" "drawing") list(2.216:0.140 2.256:0.240))
    shape = dbCreateRect(cv list("M1" "drawing") list(2.216:-0.240 2.256:-0.140))
    shape = dbCreateRect(cv list("CA" "drawing") list(2.013:-0.220 2.043:-0.160))
    shape = dbCreateRect(cv list("CA" "drawing") list(2.013:0.160 2.043:0.220))
    shape = dbCreateRect(cv list("M1" "drawing") list(1.904:-0.400 1.944:-0.340))
    shape = dbCreateRect(cv list("CA" "drawing") list(1.909:-0.320 1.939:-0.260))
    shape = dbCreateRect(cv list("M1" "drawing") list(1.904:0.340 1.944:0.400))
    shape = dbCreateRect(cv list("CA" "drawing") list(1.909:0.260 1.939:0.320))
    shape = dbCreateRect(cv list("M1" "drawing") list(2.112:-0.400 2.152:-0.340))
    shape = dbCreateRect(cv list("M1" "drawing") list(2.112:0.340 2.152:0.400))
    shape = dbCreateRect(cv list("CA" "drawing") list(2.117:-0.320 2.147:-0.260))
    shape = dbCreateRect(cv list("CA" "drawing") list(2.117:0.260 2.147:0.320))
    shape = dbCreateRect(cv list("CB" "drawing") list(2.060:-0.480 2.100:-0.440))
    shape = dbCreateRect(cv list("CB" "drawing") list(2.060:0.440 2.100:0.480))
    shape = dbCreateRect(cv list("CB" "drawing") list(1.956:-0.020 1.996:0.020))
    shape = dbCreateRect(cv list("M1" "drawing") list(1.904:-0.520 2.152:-0.400))
    shape = dbCreateRect(cv list("M1" "drawing") list(1.904:0.400 2.152:0.520))
    shape = dbCreateRect(cv list("PC" "drawing") list(2.070:-0.542 2.090:0.000))
    shape = dbCreateRect(cv list("RX" "drawing") list(1.978:-0.340 2.182:-0.140))
    shape = dbCreateRect(cv list("NPLUS" "drawing") list(1.878:-0.642 2.282:0.000))
    shape = dbCreateRect(cv list("NW" "drawing") list(1.878:-0.642 2.282:0.000))
    shape = dbCreateRect(cv list("LVTN" "drawing") list(1.878:-0.642 2.282:0.000))
    shape = dbCreateRect(cv list("CT" "drawing") list(2.028:-0.032 2.132:0.032))
    shape = dbCreateRect(cv list("PC" "drawing") list(1.966:-0.542 1.986:0.000))
    shape = dbCreateRect(cv list("RX" "drawing") list(1.874:-0.340 2.078:-0.140))
    shape = dbCreateRect(cv list("NPLUS" "drawing") list(1.774:-0.642 2.178:0.000))
    shape = dbCreateRect(cv list("NW" "drawing") list(1.774:-0.642 2.178:0.000))
    shape = dbCreateRect(cv list("LVTN" "drawing") list(1.774:-0.642 2.178:0.000))
    shape = dbCreateRect(cv list("CT" "drawing") list(1.924:-0.492 2.028:-0.428))
    shape = dbCreateRect(cv list("PC" "drawing") list(2.070:0.000 2.090:0.542))
    shape = dbCreateRect(cv list("RX" "drawing") list(1.978:0.140 2.182:0.340))
    shape = dbCreateRect(cv list("PPLUS" "drawing") list(1.878:0.000 2.282:0.642))
    shape = dbCreateRect(cv list("NW" "drawing") list(1.878:0.000 2.282:0.642))
    shape = dbCreateRect(cv list("RVTP" "drawing") list(1.878:0.000 2.282:0.642))
    shape = dbCreateRect(cv list("CT" "drawing") list(2.028:-0.032 2.132:0.032))
    shape = dbCreateRect(cv list("PC" "drawing") list(1.966:0.000 1.986:0.542))
    shape = dbCreateRect(cv list("RX" "drawing") list(1.874:0.140 2.078:0.340))
    shape = dbCreateRect(cv list("PPLUS" "drawing") list(1.774:0.000 2.178:0.642))
    shape = dbCreateRect(cv list("NW" "drawing") list(1.774:0.000 2.178:0.642))
    shape = dbCreateRect(cv list("RVTP" "drawing") list(1.774:0.000 2.178:0.642))
    shape = dbCreateRect(cv list("CT" "drawing") list(1.924:0.428 2.028:0.492))
    shape = dbCreatePolygon(cv list("M1" "drawing") list(2.028:0.140 2.060:0.140 2.060:-0.140 2.028:-0.140 2.028:-0.180 2.100:-0.180 2.100:0.180 2.028:0.180))
    shape = dbCreateRect(cv list("M1" "drawing") list(1.966:-0.020 1.986:0.020))
    shape = dbCreateRect(cv list("M1" "drawing") list(2.112:0.240 2.152:0.340))
    shape = dbCreateRect(cv list("M1" "drawing") list(2.112:-0.340 2.152:-0.240))
    shape = dbCreateRect(cv list("M1" "drawing") list(1.904:0.240 1.944:0.340))
    shape = dbCreateRect(cv list("M1" "drawing") list(1.904:-0.340 1.944:-0.240))
    shape = dbCreateRect(cv list("M1" "drawing") list(2.008:0.140 2.048:0.240))
    shape = dbCreateRect(cv list("M1" "drawing") list(2.008:-0.240 2.048:-0.140))
    shape = dbCreateRect(cv list("CA" "drawing") list(1.701:-0.220 1.731:-0.160))
    shape = dbCreateRect(cv list("CA" "drawing") list(1.701:0.160 1.731:0.220))
    shape = dbCreateRect(cv list("M1" "drawing") list(1.904:-0.400 1.944:-0.340))
    shape = dbCreateRect(cv list("CA" "drawing") list(1.909:-0.320 1.939:-0.260))
    shape = dbCreateRect(cv list("M1" "drawing") list(1.904:0.340 1.944:0.400))
    shape = dbCreateRect(cv list("CA" "drawing") list(1.909:0.260 1.939:0.320))
    shape = dbCreateRect(cv list("PC" "drawing") list(1.758:-0.460 1.778:0.000))
    shape = dbCreateRect(cv list("RX" "drawing") list(1.666:-0.340 1.870:-0.140))
    shape = dbCreateRect(cv list("NPLUS" "drawing") list(1.566:-0.560 1.970:0.000))
    shape = dbCreateRect(cv list("NW" "drawing") list(1.566:-0.560 1.970:0.000))
    shape = dbCreateRect(cv list("LVTN" "drawing") list(1.566:-0.560 1.970:0.000))
    shape = dbCreateRect(cv list("CT" "drawing") list(1.716:-0.032 1.820:0.032))
    shape = dbCreateRect(cv list("PC" "drawing") list(1.758:0.000 1.778:0.460))
    shape = dbCreateRect(cv list("RX" "drawing") list(1.666:0.140 1.870:0.340))
    shape = dbCreateRect(cv list("PPLUS" "drawing") list(1.566:0.000 1.970:0.560))
    shape = dbCreateRect(cv list("NW" "drawing") list(1.566:0.000 1.970:0.560))
    shape = dbCreateRect(cv list("RVTP" "drawing") list(1.566:0.000 1.970:0.560))
    shape = dbCreateRect(cv list("CT" "drawing") list(1.716:-0.032 1.820:0.032))
    shape = dbCreateRect(cv list("CB" "drawing") list(1.748:-0.100 1.788:-0.060))
    shape = dbCreateRect(cv list("CB" "drawing") list(1.748:0.060 1.788:0.100))
    shape = dbCreateRect(cv list("CB" "drawing") list(1.852:-0.020 1.892:0.020))
    shape = dbCreateRect(cv list("M1" "drawing") list(1.696:-0.520 1.944:-0.400))
    shape = dbCreateRect(cv list("M1" "drawing") list(1.696:0.400 1.944:0.520))
    shape = dbCreateRect(cv list("PC" "drawing") list(1.758:-0.542 1.778:0.000))
    shape = dbCreateRect(cv list("PC" "drawing") list(1.862:-0.542 1.882:0.000))
    shape = dbCreateRect(cv list("RX" "drawing") list(1.666:-0.340 1.974:-0.140))
    shape = dbCreateRect(cv list("NPLUS" "drawing") list(1.566:-0.642 2.074:0.000))
    shape = dbCreateRect(cv list("NW" "drawing") list(1.566:-0.642 2.074:0.000))
    shape = dbCreateRect(cv list("LVTN" "drawing") list(1.566:-0.642 2.074:0.000))
    shape = dbCreateRect(cv list("CT" "drawing") list(1.716:-0.492 1.924:-0.428))
    shape = dbCreateRect(cv list("PC" "drawing") list(1.758:0.000 1.778:0.542))
    shape = dbCreateRect(cv list("PC" "drawing") list(1.862:0.000 1.882:0.542))
    shape = dbCreateRect(cv list("RX" "drawing") list(1.666:0.140 1.974:0.340))
    shape = dbCreateRect(cv list("PPLUS" "drawing") list(1.566:0.000 2.074:0.642))
    shape = dbCreateRect(cv list("NW" "drawing") list(1.566:0.000 2.074:0.642))
    shape = dbCreateRect(cv list("RVTP" "drawing") list(1.566:0.000 2.074:0.642))
    shape = dbCreateRect(cv list("CT" "drawing") list(1.716:0.428 1.924:0.492))
    shape = dbCreatePolygon(cv list("M1" "drawing") list(1.716:0.180 1.436:0.180 1.436:-0.180 1.716:-0.180 1.716:-0.140 1.476:-0.140 1.476:0.140 1.716:0.140))
    shape = dbCreateRect(cv list("M1" "drawing") list(1.862:-0.020 1.882:0.020))
    shape = dbCreateRect(cv list("M1" "drawing") list(1.758:0.060 1.778:0.100))
    shape = dbCreateRect(cv list("M1" "drawing") list(1.758:-0.100 1.778:-0.060))
    shape = dbCreateRect(cv list("M1" "drawing") list(1.904:0.240 1.944:0.340))
    shape = dbCreateRect(cv list("M1" "drawing") list(1.904:-0.340 1.944:-0.240))
    shape = dbCreateRect(cv list("M1" "drawing") list(1.696:0.140 1.736:0.240))
    shape = dbCreateRect(cv list("M1" "drawing") list(1.696:-0.240 1.736:-0.140))
    shape = dbCreateRect(cv list("CB" "drawing") list(1.644:-0.480 1.684:-0.440))
    shape = dbCreateRect(cv list("CB" "drawing") list(1.644:0.440 1.684:0.480))
    shape = dbCreateRect(cv list("M1" "drawing") list(1.592:-0.520 1.736:-0.400))
    shape = dbCreateRect(cv list("M1" "drawing") list(1.592:0.400 1.736:0.520))
    shape = dbCreateRect(cv list("PC" "drawing") list(1.654:-0.542 1.674:0.000))
    shape = dbCreateRect(cv list("RX" "drawing") list(1.562:-0.340 1.766:-0.140))
    shape = dbCreateRect(cv list("NPLUS" "drawing") list(1.462:-0.642 1.866:0.000))
    shape = dbCreateRect(cv list("NW" "drawing") list(1.462:-0.642 1.866:0.000))
    shape = dbCreateRect(cv list("LVTN" "drawing") list(1.462:-0.642 1.866:0.000))
    shape = dbCreateRect(cv list("CT" "drawing") list(1.612:-0.032 1.716:0.032))
    shape = dbCreateRect(cv list("PC" "drawing") list(1.654:0.000 1.674:0.542))
    shape = dbCreateRect(cv list("RX" "drawing") list(1.562:0.140 1.766:0.340))
    shape = dbCreateRect(cv list("PPLUS" "drawing") list(1.462:0.000 1.866:0.642))
    shape = dbCreateRect(cv list("NW" "drawing") list(1.462:0.000 1.866:0.642))
    shape = dbCreateRect(cv list("RVTP" "drawing") list(1.462:0.000 1.866:0.642))
    shape = dbCreateRect(cv list("CT" "drawing") list(1.612:-0.032 1.716:0.032))
    shape = dbCreateRect(cv list("CA" "drawing") list(1.597:-0.320 1.627:-0.260))
    shape = dbCreateRect(cv list("CA" "drawing") list(1.597:0.260 1.627:0.320))
    shape = dbCreateRect(cv list("M1" "drawing") list(1.488:-0.400 1.528:-0.340))
    shape = dbCreateRect(cv list("CA" "drawing") list(1.493:-0.320 1.523:-0.260))
    shape = dbCreateRect(cv list("M1" "drawing") list(1.488:0.340 1.528:0.400))
    shape = dbCreateRect(cv list("CA" "drawing") list(1.493:0.260 1.523:0.320))
    shape = dbCreateRect(cv list("CB" "drawing") list(1.540:0.060 1.580:0.100))
    shape = dbCreateRect(cv list("M1" "drawing") list(1.488:-0.520 1.632:-0.400))
    shape = dbCreateRect(cv list("M1" "drawing") list(1.488:0.400 1.632:0.520))
    shape = dbCreateRect(cv list("PC" "drawing") list(1.550:-0.542 1.570:0.000))
    shape = dbCreateRect(cv list("RX" "drawing") list(1.458:-0.340 1.662:-0.140))
    shape = dbCreateRect(cv list("NPLUS" "drawing") list(1.358:-0.642 1.762:0.000))
    shape = dbCreateRect(cv list("NW" "drawing") list(1.358:-0.642 1.762:0.000))
    shape = dbCreateRect(cv list("LVTN" "drawing") list(1.358:-0.642 1.762:0.000))
    shape = dbCreateRect(cv list("CT" "drawing") list(1.508:-0.492 1.612:-0.428))
    shape = dbCreateRect(cv list("PC" "drawing") list(1.550:0.000 1.570:0.542))
    shape = dbCreateRect(cv list("RX" "drawing") list(1.458:0.140 1.662:0.340))
    shape = dbCreateRect(cv list("PPLUS" "drawing") list(1.358:0.000 1.762:0.642))
    shape = dbCreateRect(cv list("NW" "drawing") list(1.358:0.000 1.762:0.642))
    shape = dbCreateRect(cv list("RVTP" "drawing") list(1.358:0.000 1.762:0.642))
    shape = dbCreateRect(cv list("CT" "drawing") list(1.508:0.428 1.612:0.492))
    shape = dbCreateRect(cv list("M1" "drawing") list(1.550:0.060 1.570:0.100))
    shape = dbCreateRect(cv list("M1" "drawing") list(1.488:0.240 1.528:0.340))
    shape = dbCreateRect(cv list("M1" "drawing") list(1.488:-0.340 1.528:-0.240))
    shape = dbCreateRect(cv list("M1" "drawing") list(1.592:0.240 1.632:0.340))
    shape = dbCreateRect(cv list("M1" "drawing") list(1.592:-0.340 1.632:-0.240))
    shape = dbCreateRect(cv list("CA" "drawing") list(1.389:-0.220 1.419:-0.160))
    shape = dbCreateRect(cv list("CA" "drawing") list(1.389:0.160 1.419:0.220))
    shape = dbCreateRect(cv list("CA" "drawing") list(1.285:-0.320 1.315:-0.260))
    shape = dbCreateRect(cv list("CA" "drawing") list(1.285:0.260 1.315:0.320))
    shape = dbCreateRect(cv list("M1" "drawing") list(1.488:-0.400 1.528:-0.340))
    shape = dbCreateRect(cv list("M1" "drawing") list(1.488:0.340 1.528:0.400))
    shape = dbCreateRect(cv list("CA" "drawing") list(1.493:-0.320 1.523:-0.260))
    shape = dbCreateRect(cv list("CA" "drawing") list(1.493:0.260 1.523:0.320))
    shape = dbCreateRect(cv list("CB" "drawing") list(1.436:-0.480 1.476:-0.440))
    shape = dbCreateRect(cv list("CB" "drawing") list(1.436:0.440 1.476:0.480))
    shape = dbCreateRect(cv list("PC" "drawing") list(1.342:-0.460 1.362:0.000))
    shape = dbCreateRect(cv list("RX" "drawing") list(1.250:-0.340 1.454:-0.140))
    shape = dbCreateRect(cv list("NPLUS" "drawing") list(1.150:-0.560 1.554:0.000))
    shape = dbCreateRect(cv list("NW" "drawing") list(1.150:-0.560 1.554:0.000))
    shape = dbCreateRect(cv list("LVTN" "drawing") list(1.150:-0.560 1.554:0.000))
    shape = dbCreateRect(cv list("CT" "drawing") list(1.300:-0.032 1.404:0.032))
    shape = dbCreateRect(cv list("PC" "drawing") list(1.342:0.000 1.362:0.460))
    shape = dbCreateRect(cv list("RX" "drawing") list(1.250:0.140 1.454:0.340))
    shape = dbCreateRect(cv list("PPLUS" "drawing") list(1.150:0.000 1.554:0.560))
    shape = dbCreateRect(cv list("NW" "drawing") list(1.150:0.000 1.554:0.560))
    shape = dbCreateRect(cv list("RVTP" "drawing") list(1.150:0.000 1.554:0.560))
    shape = dbCreateRect(cv list("CT" "drawing") list(1.300:-0.032 1.404:0.032))
    shape = dbCreateRect(cv list("CB" "drawing") list(1.332:-0.100 1.372:-0.060))
    shape = dbCreateRect(cv list("CB" "drawing") list(1.332:0.060 1.372:0.100))
    shape = dbCreateRect(cv list("M1" "drawing") list(1.280:-0.520 1.528:-0.400))
    shape = dbCreateRect(cv list("M1" "drawing") list(1.280:0.400 1.528:0.520))
    shape = dbCreateRect(cv list("PC" "drawing") list(1.446:-0.542 1.466:0.000))
    shape = dbCreateRect(cv list("RX" "drawing") list(1.354:-0.340 1.558:-0.140))
    shape = dbCreateRect(cv list("NPLUS" "drawing") list(1.254:-0.642 1.658:0.000))
    shape = dbCreateRect(cv list("NW" "drawing") list(1.254:-0.642 1.658:0.000))
    shape = dbCreateRect(cv list("LVTN" "drawing") list(1.254:-0.642 1.658:0.000))
    shape = dbCreateRect(cv list("CT" "drawing") list(1.404:-0.032 1.508:0.032))
    shape = dbCreateRect(cv list("PC" "drawing") list(1.342:-0.542 1.362:0.000))
    shape = dbCreateRect(cv list("RX" "drawing") list(1.250:-0.340 1.454:-0.140))
    shape = dbCreateRect(cv list("NPLUS" "drawing") list(1.150:-0.642 1.554:0.000))
    shape = dbCreateRect(cv list("NW" "drawing") list(1.150:-0.642 1.554:0.000))
    shape = dbCreateRect(cv list("LVTN" "drawing") list(1.150:-0.642 1.554:0.000))
    shape = dbCreateRect(cv list("CT" "drawing") list(1.300:-0.492 1.404:-0.428))
    shape = dbCreateRect(cv list("PC" "drawing") list(1.446:0.000 1.466:0.542))
    shape = dbCreateRect(cv list("RX" "drawing") list(1.354:0.140 1.558:0.340))
    shape = dbCreateRect(cv list("PPLUS" "drawing") list(1.254:0.000 1.658:0.642))
    shape = dbCreateRect(cv list("NW" "drawing") list(1.254:0.000 1.658:0.642))
    shape = dbCreateRect(cv list("RVTP" "drawing") list(1.254:0.000 1.658:0.642))
    shape = dbCreateRect(cv list("CT" "drawing") list(1.404:-0.032 1.508:0.032))
    shape = dbCreateRect(cv list("PC" "drawing") list(1.342:0.000 1.362:0.542))
    shape = dbCreateRect(cv list("RX" "drawing") list(1.250:0.140 1.454:0.340))
    shape = dbCreateRect(cv list("PPLUS" "drawing") list(1.150:0.000 1.554:0.642))
    shape = dbCreateRect(cv list("NW" "drawing") list(1.150:0.000 1.554:0.642))
    shape = dbCreateRect(cv list("RVTP" "drawing") list(1.150:0.000 1.554:0.642))
    shape = dbCreateRect(cv list("CT" "drawing") list(1.300:0.428 1.404:0.492))
    shape = dbCreatePolygon(cv list("M1" "drawing") list(1.280:0.320 1.280:0.180 1.124:0.180 1.124:-0.180 1.280:-0.180 1.280:-0.320 1.320:-0.320 1.320:-0.140 1.164:-0.140 1.164:0.140 1.320:0.140 1.320:0.320))
    shape = dbCreatePolygon(cv list("M1" "drawing") list(1.404:0.140 1.436:0.140 1.436:-0.140 1.404:-0.140 1.404:-0.180 1.476:-0.180 1.476:0.180 1.404:0.180))
    shape = dbCreateRect(cv list("M1" "drawing") list(1.342:0.060 1.362:0.100))
    shape = dbCreateRect(cv list("M1" "drawing") list(1.342:-0.100 1.362:-0.060))
    shape = dbCreateRect(cv list("M1" "drawing") list(1.488:0.240 1.528:0.340))
    shape = dbCreateRect(cv list("M1" "drawing") list(1.488:-0.340 1.528:-0.240))
    shape = dbCreateRect(cv list("M1" "drawing") list(1.280:0.240 1.320:0.340))
    shape = dbCreateRect(cv list("M1" "drawing") list(1.280:-0.340 1.320:-0.240))
    shape = dbCreateRect(cv list("M1" "drawing") list(1.384:0.140 1.424:0.240))
    shape = dbCreateRect(cv list("M1" "drawing") list(1.384:-0.240 1.424:-0.140))
    shape = dbCreateRect(cv list("CB" "drawing") list(1.228:-0.480 1.268:-0.440))
    shape = dbCreateRect(cv list("CB" "drawing") list(1.228:0.440 1.268:0.480))
    shape = dbCreateRect(cv list("M1" "drawing") list(1.176:-0.520 1.320:-0.400))
    shape = dbCreateRect(cv list("M1" "drawing") list(1.176:0.400 1.320:0.520))
    shape = dbCreateRect(cv list("PC" "drawing") list(1.238:-0.542 1.258:0.000))
    shape = dbCreateRect(cv list("RX" "drawing") list(1.146:-0.340 1.350:-0.140))
    shape = dbCreateRect(cv list("NPLUS" "drawing") list(1.046:-0.642 1.450:0.000))
    shape = dbCreateRect(cv list("NW" "drawing") list(1.046:-0.642 1.450:0.000))
    shape = dbCreateRect(cv list("LVTN" "drawing") list(1.046:-0.642 1.450:0.000))
    shape = dbCreateRect(cv list("CT" "drawing") list(1.196:-0.032 1.300:0.032))
    shape = dbCreateRect(cv list("PC" "drawing") list(1.238:0.000 1.258:0.542))
    shape = dbCreateRect(cv list("RX" "drawing") list(1.146:0.140 1.350:0.340))
    shape = dbCreateRect(cv list("PPLUS" "drawing") list(1.046:0.000 1.450:0.642))
    shape = dbCreateRect(cv list("NW" "drawing") list(1.046:0.000 1.450:0.642))
    shape = dbCreateRect(cv list("RVTP" "drawing") list(1.046:0.000 1.450:0.642))
    shape = dbCreateRect(cv list("CT" "drawing") list(1.196:-0.032 1.300:0.032))
    shape = dbCreateRect(cv list("CA" "drawing") list(0.973:-0.220 1.003:-0.160))
    shape = dbCreateRect(cv list("CA" "drawing") list(0.973:0.160 1.003:0.220))
    shape = dbCreateRect(cv list("M1" "drawing") list(1.176:-0.400 1.216:-0.340))
    shape = dbCreateRect(cv list("CA" "drawing") list(1.181:-0.320 1.211:-0.260))
    shape = dbCreateRect(cv list("M1" "drawing") list(1.176:0.340 1.216:0.400))
    shape = dbCreateRect(cv list("CA" "drawing") list(1.181:0.260 1.211:0.320))
    shape = dbCreateRect(cv list("PC" "drawing") list(1.030:-0.460 1.050:0.000))
    shape = dbCreateRect(cv list("RX" "drawing") list(0.938:-0.340 1.142:-0.140))
    shape = dbCreateRect(cv list("NPLUS" "drawing") list(0.838:-0.560 1.242:0.000))
    shape = dbCreateRect(cv list("NW" "drawing") list(0.838:-0.560 1.242:0.000))
    shape = dbCreateRect(cv list("LVTN" "drawing") list(0.838:-0.560 1.242:0.000))
    shape = dbCreateRect(cv list("CT" "drawing") list(0.988:-0.032 1.092:0.032))
    shape = dbCreateRect(cv list("PC" "drawing") list(1.030:0.000 1.050:0.460))
    shape = dbCreateRect(cv list("RX" "drawing") list(0.938:0.140 1.142:0.340))
    shape = dbCreateRect(cv list("PPLUS" "drawing") list(0.838:0.000 1.242:0.560))
    shape = dbCreateRect(cv list("NW" "drawing") list(0.838:0.000 1.242:0.560))
    shape = dbCreateRect(cv list("RVTP" "drawing") list(0.838:0.000 1.242:0.560))
    shape = dbCreateRect(cv list("CT" "drawing") list(0.988:-0.032 1.092:0.032))
    shape = dbCreateRect(cv list("CB" "drawing") list(1.020:-0.100 1.060:-0.060))
    shape = dbCreateRect(cv list("CB" "drawing") list(1.020:0.060 1.060:0.100))
    shape = dbCreateRect(cv list("CB" "drawing") list(1.124:-0.020 1.164:0.020))
    shape = dbCreateRect(cv list("M1" "drawing") list(0.968:-0.520 1.216:-0.400))
    shape = dbCreateRect(cv list("M1" "drawing") list(0.968:0.400 1.216:0.520))
    shape = dbCreateRect(cv list("PC" "drawing") list(1.030:-0.542 1.050:0.000))
    shape = dbCreateRect(cv list("PC" "drawing") list(1.134:-0.542 1.154:0.000))
    shape = dbCreateRect(cv list("RX" "drawing") list(0.938:-0.340 1.246:-0.140))
    shape = dbCreateRect(cv list("NPLUS" "drawing") list(0.838:-0.642 1.346:0.000))
    shape = dbCreateRect(cv list("NW" "drawing") list(0.838:-0.642 1.346:0.000))
    shape = dbCreateRect(cv list("LVTN" "drawing") list(0.838:-0.642 1.346:0.000))
    shape = dbCreateRect(cv list("CT" "drawing") list(0.988:-0.492 1.196:-0.428))
    shape = dbCreateRect(cv list("PC" "drawing") list(1.030:0.000 1.050:0.542))
    shape = dbCreateRect(cv list("PC" "drawing") list(1.134:0.000 1.154:0.542))
    shape = dbCreateRect(cv list("RX" "drawing") list(0.938:0.140 1.246:0.340))
    shape = dbCreateRect(cv list("PPLUS" "drawing") list(0.838:0.000 1.346:0.642))
    shape = dbCreateRect(cv list("NW" "drawing") list(0.838:0.000 1.346:0.642))
    shape = dbCreateRect(cv list("RVTP" "drawing") list(0.838:0.000 1.346:0.642))
    shape = dbCreateRect(cv list("CT" "drawing") list(0.988:0.428 1.196:0.492))
    shape = dbCreatePolygon(cv list("M1" "drawing") list(0.988:0.180 0.812:0.180 0.812:-0.180 0.988:-0.180 0.988:-0.140 0.852:-0.140 0.852:0.140 0.988:0.140))
    shape = dbCreateRect(cv list("M1" "drawing") list(1.134:-0.020 1.154:0.020))
    shape = dbCreateRect(cv list("M1" "drawing") list(1.030:0.060 1.050:0.100))
    shape = dbCreateRect(cv list("M1" "drawing") list(1.030:-0.100 1.050:-0.060))
    shape = dbCreateRect(cv list("M1" "drawing") list(1.176:0.240 1.216:0.340))
    shape = dbCreateRect(cv list("M1" "drawing") list(1.176:-0.340 1.216:-0.240))
    shape = dbCreateRect(cv list("M1" "drawing") list(0.968:0.140 1.008:0.240))
    shape = dbCreateRect(cv list("M1" "drawing") list(0.968:-0.240 1.008:-0.140))
    shape = dbCreateRect(cv list("CB" "drawing") list(0.916:-0.480 0.956:-0.440))
    shape = dbCreateRect(cv list("CB" "drawing") list(0.916:0.440 0.956:0.480))
    shape = dbCreateRect(cv list("M1" "drawing") list(0.864:-0.520 1.008:-0.400))
    shape = dbCreateRect(cv list("M1" "drawing") list(0.864:0.400 1.008:0.520))
    shape = dbCreateRect(cv list("PC" "drawing") list(0.926:-0.542 0.946:0.000))
    shape = dbCreateRect(cv list("RX" "drawing") list(0.834:-0.340 1.038:-0.140))
    shape = dbCreateRect(cv list("NPLUS" "drawing") list(0.734:-0.642 1.138:0.000))
    shape = dbCreateRect(cv list("NW" "drawing") list(0.734:-0.642 1.138:0.000))
    shape = dbCreateRect(cv list("LVTN" "drawing") list(0.734:-0.642 1.138:0.000))
    shape = dbCreateRect(cv list("CT" "drawing") list(0.884:-0.032 0.988:0.032))
    shape = dbCreateRect(cv list("PC" "drawing") list(0.926:0.000 0.946:0.542))
    shape = dbCreateRect(cv list("RX" "drawing") list(0.834:0.140 1.038:0.340))
    shape = dbCreateRect(cv list("PPLUS" "drawing") list(0.734:0.000 1.138:0.642))
    shape = dbCreateRect(cv list("NW" "drawing") list(0.734:0.000 1.138:0.642))
    shape = dbCreateRect(cv list("RVTP" "drawing") list(0.734:0.000 1.138:0.642))
    shape = dbCreateRect(cv list("CT" "drawing") list(0.884:-0.032 0.988:0.032))
    shape = dbCreateRect(cv list("CA" "drawing") list(0.869:-0.320 0.899:-0.260))
    shape = dbCreateRect(cv list("CA" "drawing") list(0.869:0.260 0.899:0.320))
    shape = dbCreateRect(cv list("M1" "drawing") list(0.760:-0.400 0.800:-0.340))
    shape = dbCreateRect(cv list("CA" "drawing") list(0.765:-0.320 0.795:-0.260))
    shape = dbCreateRect(cv list("M1" "drawing") list(0.760:0.340 0.800:0.400))
    shape = dbCreateRect(cv list("CA" "drawing") list(0.765:0.260 0.795:0.320))
    shape = dbCreateRect(cv list("CB" "drawing") list(0.812:-0.020 0.852:0.020))
    shape = dbCreateRect(cv list("M1" "drawing") list(0.760:-0.520 0.904:-0.400))
    shape = dbCreateRect(cv list("M1" "drawing") list(0.760:0.400 0.904:0.520))
    shape = dbCreateRect(cv list("PC" "drawing") list(0.822:-0.542 0.842:0.000))
    shape = dbCreateRect(cv list("RX" "drawing") list(0.730:-0.340 0.934:-0.140))
    shape = dbCreateRect(cv list("NPLUS" "drawing") list(0.630:-0.642 1.034:0.000))
    shape = dbCreateRect(cv list("NW" "drawing") list(0.630:-0.642 1.034:0.000))
    shape = dbCreateRect(cv list("LVTN" "drawing") list(0.630:-0.642 1.034:0.000))
    shape = dbCreateRect(cv list("CT" "drawing") list(0.780:-0.492 0.884:-0.428))
    shape = dbCreateRect(cv list("PC" "drawing") list(0.822:0.000 0.842:0.542))
    shape = dbCreateRect(cv list("RX" "drawing") list(0.730:0.140 0.934:0.340))
    shape = dbCreateRect(cv list("PPLUS" "drawing") list(0.630:0.000 1.034:0.642))
    shape = dbCreateRect(cv list("NW" "drawing") list(0.630:0.000 1.034:0.642))
    shape = dbCreateRect(cv list("RVTP" "drawing") list(0.630:0.000 1.034:0.642))
    shape = dbCreateRect(cv list("CT" "drawing") list(0.780:0.428 0.884:0.492))
    shape = dbCreateRect(cv list("M1" "drawing") list(0.822:-0.020 0.842:0.020))
    shape = dbCreateRect(cv list("M1" "drawing") list(0.760:0.240 0.800:0.340))
    shape = dbCreateRect(cv list("M1" "drawing") list(0.760:-0.340 0.800:-0.240))
    shape = dbCreateRect(cv list("M1" "drawing") list(0.864:0.240 0.904:0.340))
    shape = dbCreateRect(cv list("M1" "drawing") list(0.864:-0.340 0.904:-0.240))
    shape = dbCreateRect(cv list("CA" "drawing") list(0.661:-0.220 0.691:-0.160))
    shape = dbCreateRect(cv list("CA" "drawing") list(0.661:0.160 0.691:0.220))
    shape = dbCreateRect(cv list("CA" "drawing") list(0.557:-0.320 0.587:-0.260))
    shape = dbCreateRect(cv list("CA" "drawing") list(0.453:-0.320 0.483:-0.260))
    shape = dbCreateRect(cv list("M1" "drawing") list(0.448:0.340 0.488:0.400))
    shape = dbCreateRect(cv list("CA" "drawing") list(0.453:0.260 0.483:0.320))
    shape = dbCreateRect(cv list("M1" "drawing") list(0.344:-0.400 0.384:-0.340))
    shape = dbCreateRect(cv list("CA" "drawing") list(0.349:-0.320 0.379:-0.260))
    shape = dbCreateRect(cv list("M1" "drawing") list(0.760:-0.400 0.800:-0.340))
    shape = dbCreateRect(cv list("M1" "drawing") list(0.760:0.340 0.800:0.400))
    shape = dbCreateRect(cv list("CA" "drawing") list(0.765:-0.320 0.795:-0.260))
    shape = dbCreateRect(cv list("CA" "drawing") list(0.765:0.260 0.795:0.320))
    shape = dbCreateRect(cv list("CB" "drawing") list(0.708:-0.480 0.748:-0.440))
    shape = dbCreateRect(cv list("CB" "drawing") list(0.708:0.440 0.748:0.480))
    shape = dbCreateRect(cv list("CB" "drawing") list(0.604:-0.100 0.644:-0.060))
    shape = dbCreateRect(cv list("CB" "drawing") list(0.500:-0.020 0.540:0.020))
    shape = dbCreateRect(cv list("CB" "drawing") list(0.396:0.060 0.436:0.100))
    shape = dbCreateRect(cv list("M1" "drawing") list(0.344:-0.520 0.800:-0.400))
    shape = dbCreateRect(cv list("M1" "drawing") list(0.344:0.400 0.800:0.520))
    shape = dbCreateRect(cv list("PC" "drawing") list(0.718:-0.542 0.738:0.000))
    shape = dbCreateRect(cv list("RX" "drawing") list(0.626:-0.340 0.830:-0.140))
    shape = dbCreateRect(cv list("NPLUS" "drawing") list(0.526:-0.642 0.930:0.000))
    shape = dbCreateRect(cv list("NW" "drawing") list(0.526:-0.642 0.930:0.000))
    shape = dbCreateRect(cv list("LVTN" "drawing") list(0.526:-0.642 0.930:0.000))
    shape = dbCreateRect(cv list("CT" "drawing") list(0.676:-0.032 0.780:0.032))
    shape = dbCreateRect(cv list("PC" "drawing") list(0.614:-0.542 0.634:0.000))
    shape = dbCreateRect(cv list("PC" "drawing") list(0.510:-0.542 0.530:0.000))
    shape = dbCreateRect(cv list("PC" "drawing") list(0.406:-0.542 0.426:0.000))
    shape = dbCreateRect(cv list("RX" "drawing") list(0.314:-0.340 0.726:-0.140))
    shape = dbCreateRect(cv list("NPLUS" "drawing") list(0.214:-0.642 0.826:0.000))
    shape = dbCreateRect(cv list("NW" "drawing") list(0.214:-0.642 0.826:0.000))
    shape = dbCreateRect(cv list("LVTN" "drawing") list(0.214:-0.642 0.826:0.000))
    shape = dbCreateRect(cv list("CT" "drawing") list(0.364:-0.492 0.676:-0.428))
    shape = dbCreateRect(cv list("PC" "drawing") list(0.718:0.000 0.738:0.542))
    shape = dbCreateRect(cv list("RX" "drawing") list(0.626:0.140 0.830:0.340))
    shape = dbCreateRect(cv list("PPLUS" "drawing") list(0.526:0.000 0.930:0.642))
    shape = dbCreateRect(cv list("NW" "drawing") list(0.526:0.000 0.930:0.642))
    shape = dbCreateRect(cv list("RVTP" "drawing") list(0.526:0.000 0.930:0.642))
    shape = dbCreateRect(cv list("CT" "drawing") list(0.676:-0.032 0.780:0.032))
    shape = dbCreateRect(cv list("PC" "drawing") list(0.614:0.000 0.634:0.542))
    shape = dbCreateRect(cv list("PC" "drawing") list(0.510:0.000 0.530:0.542))
    shape = dbCreateRect(cv list("PC" "drawing") list(0.406:0.000 0.426:0.542))
    shape = dbCreateRect(cv list("RX" "drawing") list(0.314:0.140 0.726:0.340))
    shape = dbCreateRect(cv list("PPLUS" "drawing") list(0.214:0.000 0.826:0.642))
    shape = dbCreateRect(cv list("NW" "drawing") list(0.214:0.000 0.826:0.642))
    shape = dbCreateRect(cv list("RVTP" "drawing") list(0.214:0.000 0.826:0.642))
    shape = dbCreateRect(cv list("CT" "drawing") list(0.364:0.428 0.676:0.492))
    shape = dbCreatePolygon(cv list("M1" "drawing") list(0.676:0.140 0.812:0.140 0.812:-0.140 0.676:-0.140 0.676:-0.180 0.852:-0.180 0.852:0.180 0.676:0.180))
    shape = dbCreateRect(cv list("M1" "drawing") list(0.468:-0.310 0.572:-0.270))
    shape = dbCreateRect(cv list("M1" "drawing") list(0.406:0.060 0.426:0.100))
    shape = dbCreateRect(cv list("M1" "drawing") list(0.510:-0.020 0.530:0.020))
    shape = dbCreateRect(cv list("M1" "drawing") list(0.614:-0.100 0.634:-0.060))
    shape = dbCreateRect(cv list("M1" "drawing") list(0.760:0.240 0.800:0.340))
    shape = dbCreateRect(cv list("M1" "drawing") list(0.760:-0.340 0.800:-0.240))
    shape = dbCreateRect(cv list("M1" "drawing") list(0.344:-0.340 0.384:-0.240))
    shape = dbCreateRect(cv list("M1" "drawing") list(0.448:0.240 0.488:0.340))
    shape = dbCreateRect(cv list("M1" "drawing") list(0.448:-0.340 0.488:-0.240))
    shape = dbCreateRect(cv list("M1" "drawing") list(0.552:-0.340 0.592:-0.240))
    shape = dbCreateRect(cv list("M1" "drawing") list(0.656:0.140 0.696:0.240))
    shape = dbCreateRect(cv list("M1" "drawing") list(0.656:-0.240 0.696:-0.140))
    shape = dbCreateRect(cv list("CA" "drawing") list(0.245:-0.220 0.275:-0.160))
    shape = dbCreateRect(cv list("CA" "drawing") list(0.245:0.160 0.275:0.220))
    shape = dbCreateRect(cv list("M1" "drawing") list(0.136:-0.400 0.176:-0.340))
    shape = dbCreateRect(cv list("CA" "drawing") list(0.141:-0.320 0.171:-0.260))
    shape = dbCreateRect(cv list("M1" "drawing") list(0.136:0.340 0.176:0.400))
    shape = dbCreateRect(cv list("CA" "drawing") list(0.141:0.260 0.171:0.320))
    shape = dbCreateRect(cv list("M1" "drawing") list(0.344:-0.400 0.384:-0.340))
    shape = dbCreateRect(cv list("M1" "drawing") list(0.344:0.340 0.384:0.400))
    shape = dbCreateRect(cv list("CA" "drawing") list(0.349:-0.320 0.379:-0.260))
    shape = dbCreateRect(cv list("CA" "drawing") list(0.349:0.260 0.379:0.320))
    shape = dbCreateRect(cv list("CB" "drawing") list(0.292:-0.480 0.332:-0.440))
    shape = dbCreateRect(cv list("CB" "drawing") list(0.292:0.440 0.332:0.480))
    shape = dbCreateRect(cv list("CB" "drawing") list(0.188:-0.020 0.228:0.020))
    shape = dbCreateRect(cv list("M1" "drawing") list(0.136:-0.520 0.384:-0.400))
    shape = dbCreateRect(cv list("M1" "drawing") list(0.136:0.400 0.384:0.520))
    shape = dbCreateRect(cv list("PC" "drawing") list(0.302:-0.542 0.322:0.000))
    shape = dbCreateRect(cv list("RX" "drawing") list(0.210:-0.340 0.414:-0.140))
    shape = dbCreateRect(cv list("NPLUS" "drawing") list(0.110:-0.642 0.514:0.000))
    shape = dbCreateRect(cv list("NW" "drawing") list(0.110:-0.642 0.514:0.000))
    shape = dbCreateRect(cv list("LVTN" "drawing") list(0.110:-0.642 0.514:0.000))
    shape = dbCreateRect(cv list("CT" "drawing") list(0.260:-0.032 0.364:0.032))
    shape = dbCreateRect(cv list("PC" "drawing") list(0.198:-0.542 0.218:0.000))
    shape = dbCreateRect(cv list("RX" "drawing") list(0.106:-0.340 0.310:-0.140))
    shape = dbCreateRect(cv list("NPLUS" "drawing") list(0.006:-0.642 0.410:0.000))
    shape = dbCreateRect(cv list("NW" "drawing") list(0.006:-0.642 0.410:0.000))
    shape = dbCreateRect(cv list("LVTN" "drawing") list(0.006:-0.642 0.410:0.000))
    shape = dbCreateRect(cv list("CT" "drawing") list(0.156:-0.492 0.260:-0.428))
    shape = dbCreateRect(cv list("PC" "drawing") list(0.302:0.000 0.322:0.542))
    shape = dbCreateRect(cv list("RX" "drawing") list(0.210:0.140 0.414:0.340))
    shape = dbCreateRect(cv list("PPLUS" "drawing") list(0.110:0.000 0.514:0.642))
    shape = dbCreateRect(cv list("NW" "drawing") list(0.110:0.000 0.514:0.642))
    shape = dbCreateRect(cv list("RVTP" "drawing") list(0.110:0.000 0.514:0.642))
    shape = dbCreateRect(cv list("CT" "drawing") list(0.260:-0.032 0.364:0.032))
    shape = dbCreateRect(cv list("PC" "drawing") list(0.198:0.000 0.218:0.542))
    shape = dbCreateRect(cv list("RX" "drawing") list(0.106:0.140 0.310:0.340))
    shape = dbCreateRect(cv list("PPLUS" "drawing") list(0.006:0.000 0.410:0.642))
    shape = dbCreateRect(cv list("NW" "drawing") list(0.006:0.000 0.410:0.642))
    shape = dbCreateRect(cv list("RVTP" "drawing") list(0.006:0.000 0.410:0.642))
    shape = dbCreateRect(cv list("CT" "drawing") list(0.156:0.428 0.260:0.492))
    shape = dbCreatePolygon(cv list("M1" "drawing") list(0.260:0.140 0.292:0.140 0.292:-0.140 0.260:-0.140 0.260:-0.180 0.332:-0.180 0.332:0.180 0.260:0.180))
    shape = dbCreateRect(cv list("M1" "drawing") list(0.198:-0.020 0.218:0.020))
    shape = dbCreateRect(cv list("M1" "drawing") list(0.344:0.240 0.384:0.340))
    shape = dbCreateRect(cv list("M1" "drawing") list(0.344:-0.340 0.384:-0.240))
    shape = dbCreateRect(cv list("M1" "drawing") list(0.136:0.240 0.176:0.340))
    shape = dbCreateRect(cv list("M1" "drawing") list(0.136:-0.340 0.176:-0.240))
    shape = dbCreateRect(cv list("M1" "drawing") list(0.240:0.140 0.280:0.240))
    shape = dbCreateRect(cv list("M1" "drawing") list(0.240:-0.240 0.280:-0.140))
    shape = dbCreateRect(cv list("CA" "drawing") list(0.037:-0.220 0.067:-0.160))
    shape = dbCreateRect(cv list("CA" "drawing") list(0.037:0.160 0.067:0.220))
    shape = dbCreateRect(cv list("M1" "drawing") list(-0.072:-0.400 -0.032:-0.340))
    shape = dbCreateRect(cv list("CA" "drawing") list(-0.067:-0.320 -0.037:-0.260))
    shape = dbCreateRect(cv list("M1" "drawing") list(-0.072:0.340 -0.032:0.400))
    shape = dbCreateRect(cv list("CA" "drawing") list(-0.067:0.260 -0.037:0.320))
    shape = dbCreateRect(cv list("M1" "drawing") list(0.136:-0.400 0.176:-0.340))
    shape = dbCreateRect(cv list("M1" "drawing") list(0.136:0.340 0.176:0.400))
    shape = dbCreateRect(cv list("CA" "drawing") list(0.141:-0.320 0.171:-0.260))
    shape = dbCreateRect(cv list("CA" "drawing") list(0.141:0.260 0.171:0.320))
    shape = dbCreateRect(cv list("CB" "drawing") list(0.084:-0.480 0.124:-0.440))
    shape = dbCreateRect(cv list("CB" "drawing") list(0.084:0.440 0.124:0.480))
    shape = dbCreateRect(cv list("CB" "drawing") list(-0.020:-0.100 0.020:-0.060))
    shape = dbCreateRect(cv list("M1" "drawing") list(-0.072:-0.520 0.176:-0.400))
    shape = dbCreateRect(cv list("M1" "drawing") list(-0.072:0.400 0.176:0.520))
    shape = dbCreateRect(cv list("PC" "drawing") list(0.094:-0.542 0.114:0.000))
    shape = dbCreateRect(cv list("RX" "drawing") list(0.002:-0.340 0.206:-0.140))
    shape = dbCreateRect(cv list("NPLUS" "drawing") list(-0.098:-0.642 0.306:0.000))
    shape = dbCreateRect(cv list("NW" "drawing") list(-0.098:-0.642 0.306:0.000))
    shape = dbCreateRect(cv list("LVTN" "drawing") list(-0.098:-0.642 0.306:0.000))
    shape = dbCreateRect(cv list("CT" "drawing") list(0.052:-0.032 0.156:0.032))
    shape = dbCreateRect(cv list("PC" "drawing") list(-0.010:-0.542 0.010:0.000))
    shape = dbCreateRect(cv list("RX" "drawing") list(-0.102:-0.340 0.102:-0.140))
    shape = dbCreateRect(cv list("NPLUS" "drawing") list(-0.202:-0.642 0.202:0.000))
    shape = dbCreateRect(cv list("NW" "drawing") list(-0.202:-0.642 0.202:0.000))
    shape = dbCreateRect(cv list("LVTN" "drawing") list(-0.202:-0.642 0.202:0.000))
    shape = dbCreateRect(cv list("CT" "drawing") list(-0.052:-0.492 0.052:-0.428))
    shape = dbCreateRect(cv list("PC" "drawing") list(0.094:0.000 0.114:0.542))
    shape = dbCreateRect(cv list("RX" "drawing") list(0.002:0.140 0.206:0.340))
    shape = dbCreateRect(cv list("PPLUS" "drawing") list(-0.098:0.000 0.306:0.642))
    shape = dbCreateRect(cv list("NW" "drawing") list(-0.098:0.000 0.306:0.642))
    shape = dbCreateRect(cv list("RVTP" "drawing") list(-0.098:0.000 0.306:0.642))
    shape = dbCreateRect(cv list("CT" "drawing") list(0.052:-0.032 0.156:0.032))
    shape = dbCreateRect(cv list("PC" "drawing") list(-0.010:0.000 0.010:0.542))
    shape = dbCreateRect(cv list("RX" "drawing") list(-0.102:0.140 0.102:0.340))
    shape = dbCreateRect(cv list("PPLUS" "drawing") list(-0.202:0.000 0.202:0.642))
    shape = dbCreateRect(cv list("NW" "drawing") list(-0.202:0.000 0.202:0.642))
    shape = dbCreateRect(cv list("RVTP" "drawing") list(-0.202:0.000 0.202:0.642))
    shape = dbCreateRect(cv list("CT" "drawing") list(-0.052:0.428 0.052:0.492))
    shape = dbCreatePolygon(cv list("M1" "drawing") list(0.052:0.140 0.084:0.140 0.084:-0.140 0.052:-0.140 0.052:-0.180 0.124:-0.180 0.124:0.180 0.052:0.180))
    shape = dbCreateRect(cv list("M1" "drawing") list(-0.010:-0.100 0.010:-0.060))
    shape = dbCreateRect(cv list("M1" "drawing") list(0.136:0.240 0.176:0.340))
    shape = dbCreateRect(cv list("M1" "drawing") list(0.136:-0.340 0.176:-0.240))
    shape = dbCreateRect(cv list("M1" "drawing") list(-0.072:0.240 -0.032:0.340))
    shape = dbCreateRect(cv list("M1" "drawing") list(-0.072:-0.340 -0.032:-0.240))
    shape = dbCreateRect(cv list("M1" "drawing") list(0.032:0.140 0.072:0.240))
    shape = dbCreateRect(cv list("M1" "drawing") list(0.032:-0.240 0.072:-0.140))
    shape = dbCreateRect(cv list("M2" "drawing") list(-0.228:-0.100 -0.188:-0.060))
    shape = dbCreateRect(cv list("M1" "drawing") list(-0.228:-0.100 -0.188:-0.060))
    shape = dbCreateRect(cv list("M2" "drawing") list(-0.852:-0.020 -0.812:0.020))
    shape = dbCreateRect(cv list("M1" "drawing") list(-0.852:-0.020 -0.812:0.020))
    shape = dbCreateRect(cv list("V1" "drawing") list(-0.872:-0.020 -0.792:0.020))
    shape = dbCreateRect(cv list("V1" "drawing") list(-0.248:-0.100 -0.168:-0.060))
    shape = dbCreatePolygon(cv list("M2" "drawing") list(-0.852:0.000 -0.852:-0.180 -0.188:-0.180 -0.188:-0.080 -0.228:-0.080 -0.228:-0.140 -0.812:-0.140 -0.812:0.000))
    shape = dbCreatePolygon(cv list("M1" "drawing") list(-0.292:0.000 -0.292:0.060 -0.104:0.060 -0.104:0.100 -0.332:0.100 -0.332:0.000))
    shape = dbCreatePolygon(cv list("M1" "drawing") list(-1.332:0.000 -1.332:0.060 -1.144:0.060 -1.144:0.100 -1.372:0.100 -1.372:0.000))
    shape = dbCreateRect(cv list("M1" "drawing") list(-0.072:-0.400 -0.032:-0.340))
    shape = dbCreateRect(cv list("CA" "drawing") list(-0.067:-0.320 -0.037:-0.260))
    shape = dbCreateRect(cv list("M1" "drawing") list(-0.072:0.340 -0.032:0.400))
    shape = dbCreateRect(cv list("CA" "drawing") list(-0.067:0.260 -0.037:0.320))
    shape = dbCreateRect(cv list("CA" "drawing") list(-0.171:0.160 -0.141:0.220))
    shape = dbCreateRect(cv list("CA" "drawing") list(-0.275:-0.220 -0.245:-0.160))
    shape = dbCreateRect(cv list("M1" "drawing") list(-0.280:0.340 -0.240:0.400))
    shape = dbCreateRect(cv list("CA" "drawing") list(-0.275:0.260 -0.245:0.320))
    shape = dbCreateRect(cv list("CB" "drawing") list(-0.124:0.060 -0.084:0.100))
    shape = dbCreateRect(cv list("CB" "drawing") list(-0.228:-0.100 -0.188:-0.060))
    shape = dbCreateRect(cv list("M1" "drawing") list(-0.280:-0.520 -0.032:-0.400))
    shape = dbCreateRect(cv list("M1" "drawing") list(-0.280:0.400 -0.032:0.520))
    shape = dbCreateRect(cv list("PC" "drawing") list(-0.114:-0.542 -0.094:0.000))
    shape = dbCreateRect(cv list("PC" "drawing") list(-0.218:-0.542 -0.198:0.000))
    shape = dbCreateRect(cv list("RX" "drawing") list(-0.310:-0.340 -0.002:-0.140))
    shape = dbCreateRect(cv list("NPLUS" "drawing") list(-0.410:-0.642 0.098:0.000))
    shape = dbCreateRect(cv list("NW" "drawing") list(-0.410:-0.642 0.098:0.000))
    shape = dbCreateRect(cv list("LVTN" "drawing") list(-0.410:-0.642 0.098:0.000))
    shape = dbCreateRect(cv list("CT" "drawing") list(-0.260:-0.492 -0.052:-0.428))
    shape = dbCreateRect(cv list("PC" "drawing") list(-0.114:0.000 -0.094:0.542))
    shape = dbCreateRect(cv list("PC" "drawing") list(-0.218:0.000 -0.198:0.542))
    shape = dbCreateRect(cv list("RX" "drawing") list(-0.310:0.140 -0.002:0.340))
    shape = dbCreateRect(cv list("PPLUS" "drawing") list(-0.410:0.000 0.098:0.642))
    shape = dbCreateRect(cv list("NW" "drawing") list(-0.410:0.000 0.098:0.642))
    shape = dbCreateRect(cv list("RVTP" "drawing") list(-0.410:0.000 0.098:0.642))
    shape = dbCreateRect(cv list("CT" "drawing") list(-0.260:0.428 -0.052:0.492))
    shape = dbCreateRect(cv list("M1" "drawing") list(-0.252:0.060 -0.060:0.100))
    shape = dbCreateRect(cv list("M1" "drawing") list(-0.252:-0.100 -0.060:-0.060))
    shape = dbCreatePolygon(cv list("M1" "drawing") list(-0.260:-0.180 0.020:-0.180 0.020:0.180 -0.156:0.180 -0.156:0.140 -0.020:0.140 -0.020:-0.140 -0.260:-0.140))
    shape = dbCreateRect(cv list("M1" "drawing") list(-0.218:-0.100 -0.198:-0.060))
    shape = dbCreateRect(cv list("M1" "drawing") list(-0.114:0.060 -0.094:0.100))
    shape = dbCreateRect(cv list("M1" "drawing") list(-0.280:0.240 -0.240:0.340))
    shape = dbCreateRect(cv list("M1" "drawing") list(-0.280:-0.240 -0.240:-0.140))
    shape = dbCreateRect(cv list("M1" "drawing") list(-0.176:0.140 -0.136:0.240))
    shape = dbCreateRect(cv list("M1" "drawing") list(-0.072:0.240 -0.032:0.340))
    shape = dbCreateRect(cv list("M1" "drawing") list(-0.072:-0.340 -0.032:-0.240))
    shape = dbCreateRect(cv list("CB" "drawing") list(-0.332:-0.480 -0.292:-0.440))
    shape = dbCreateRect(cv list("CB" "drawing") list(-0.332:0.440 -0.292:0.480))
    shape = dbCreateRect(cv list("M1" "drawing") list(-0.384:-0.520 -0.240:-0.400))
    shape = dbCreateRect(cv list("M1" "drawing") list(-0.384:0.400 -0.240:0.520))
    shape = dbCreateRect(cv list("PC" "drawing") list(-0.322:-0.542 -0.302:0.000))
    shape = dbCreateRect(cv list("RX" "drawing") list(-0.414:-0.340 -0.210:-0.140))
    shape = dbCreateRect(cv list("NPLUS" "drawing") list(-0.514:-0.642 -0.110:0.000))
    shape = dbCreateRect(cv list("NW" "drawing") list(-0.514:-0.642 -0.110:0.000))
    shape = dbCreateRect(cv list("LVTN" "drawing") list(-0.514:-0.642 -0.110:0.000))
    shape = dbCreateRect(cv list("CT" "drawing") list(-0.364:-0.032 -0.260:0.032))
    shape = dbCreateRect(cv list("PC" "drawing") list(-0.322:0.000 -0.302:0.542))
    shape = dbCreateRect(cv list("RX" "drawing") list(-0.414:0.140 -0.210:0.340))
    shape = dbCreateRect(cv list("PPLUS" "drawing") list(-0.514:0.000 -0.110:0.642))
    shape = dbCreateRect(cv list("NW" "drawing") list(-0.514:0.000 -0.110:0.642))
    shape = dbCreateRect(cv list("RVTP" "drawing") list(-0.514:0.000 -0.110:0.642))
    shape = dbCreateRect(cv list("CT" "drawing") list(-0.364:-0.032 -0.260:0.032))
    shape = dbCreateRect(cv list("M1" "drawing") list(-0.592:-0.340 -0.552:-0.240))
    shape = dbCreateRect(cv list("M1" "drawing") list(-0.592:0.240 -0.552:0.340))
    shape = dbCreateRect(cv list("M1" "drawing") list(-0.696:-0.240 -0.656:-0.140))
    shape = dbCreateRect(cv list("M1" "drawing") list(-0.800:-0.340 -0.760:-0.240))
    shape = dbCreateRect(cv list("M1" "drawing") list(-0.800:0.140 -0.760:0.240))
    shape = dbCreateRect(cv list("M1" "drawing") list(-0.634:0.060 -0.614:0.100))
    shape = dbCreateRect(cv list("M1" "drawing") list(-0.738:-0.100 -0.718:-0.060))
    shape = dbCreatePolygon(cv list("M1" "drawing") list(-0.780:0.140 -0.540:0.140 -0.540:-0.140 -0.676:-0.140 -0.676:-0.180 -0.500:-0.180 -0.500:0.180 -0.780:0.180))
    shape = dbCreateRect(cv list("M1" "drawing") list(-0.772:-0.100 -0.580:-0.060))
    shape = dbCreateRect(cv list("M1" "drawing") list(-0.772:0.060 -0.580:0.100))
    shape = dbCreateRect(cv list("CT" "drawing") list(-0.780:0.428 -0.572:0.492))
    shape = dbCreateRect(cv list("RVTP" "drawing") list(-0.930:0.000 -0.422:0.642))
    shape = dbCreateRect(cv list("NW" "drawing") list(-0.930:0.000 -0.422:0.642))
    shape = dbCreateRect(cv list("PPLUS" "drawing") list(-0.930:0.000 -0.422:0.642))
    shape = dbCreateRect(cv list("RX" "drawing") list(-0.830:0.140 -0.522:0.340))
    shape = dbCreateRect(cv list("PC" "drawing") list(-0.738:0.000 -0.718:0.542))
    shape = dbCreateRect(cv list("PC" "drawing") list(-0.634:0.000 -0.614:0.542))
    shape = dbCreateRect(cv list("CT" "drawing") list(-0.780:-0.492 -0.572:-0.428))
    shape = dbCreateRect(cv list("LVTN" "drawing") list(-0.930:-0.642 -0.422:0.000))
    shape = dbCreateRect(cv list("NW" "drawing") list(-0.930:-0.642 -0.422:0.000))
    shape = dbCreateRect(cv list("NPLUS" "drawing") list(-0.930:-0.642 -0.422:0.000))
    shape = dbCreateRect(cv list("RX" "drawing") list(-0.830:-0.340 -0.522:-0.140))
    shape = dbCreateRect(cv list("PC" "drawing") list(-0.738:-0.542 -0.718:0.000))
    shape = dbCreateRect(cv list("PC" "drawing") list(-0.634:-0.542 -0.614:0.000))
    shape = dbCreateRect(cv list("M1" "drawing") list(-0.800:0.400 -0.552:0.520))
    shape = dbCreateRect(cv list("M1" "drawing") list(-0.800:-0.520 -0.552:-0.400))
    shape = dbCreateRect(cv list("CB" "drawing") list(-0.748:-0.100 -0.708:-0.060))
    shape = dbCreateRect(cv list("CB" "drawing") list(-0.644:0.060 -0.604:0.100))
    shape = dbCreateRect(cv list("CA" "drawing") list(-0.795:0.160 -0.765:0.220))
    shape = dbCreateRect(cv list("CA" "drawing") list(-0.795:-0.320 -0.765:-0.260))
    shape = dbCreateRect(cv list("M1" "drawing") list(-0.800:-0.400 -0.760:-0.340))
    shape = dbCreateRect(cv list("CA" "drawing") list(-0.691:-0.220 -0.661:-0.160))
    shape = dbCreateRect(cv list("CA" "drawing") list(-0.587:0.260 -0.557:0.320))
    shape = dbCreateRect(cv list("M1" "drawing") list(-0.592:0.340 -0.552:0.400))
    shape = dbCreateRect(cv list("CA" "drawing") list(-0.587:-0.320 -0.557:-0.260))
    shape = dbCreateRect(cv list("M1" "drawing") list(-0.592:-0.400 -0.552:-0.340))
    shape = dbCreateRect(cv list("CT" "drawing") list(-0.572:-0.032 -0.468:0.032))
    shape = dbCreateRect(cv list("RVTP" "drawing") list(-0.722:0.000 -0.318:0.642))
    shape = dbCreateRect(cv list("NW" "drawing") list(-0.722:0.000 -0.318:0.642))
    shape = dbCreateRect(cv list("PPLUS" "drawing") list(-0.722:0.000 -0.318:0.642))
    shape = dbCreateRect(cv list("RX" "drawing") list(-0.622:0.140 -0.418:0.340))
    shape = dbCreateRect(cv list("PC" "drawing") list(-0.530:0.000 -0.510:0.542))
    shape = dbCreateRect(cv list("CT" "drawing") list(-0.572:-0.032 -0.468:0.032))
    shape = dbCreateRect(cv list("LVTN" "drawing") list(-0.722:-0.642 -0.318:0.000))
    shape = dbCreateRect(cv list("NW" "drawing") list(-0.722:-0.642 -0.318:0.000))
    shape = dbCreateRect(cv list("NPLUS" "drawing") list(-0.722:-0.642 -0.318:0.000))
    shape = dbCreateRect(cv list("RX" "drawing") list(-0.622:-0.340 -0.418:-0.140))
    shape = dbCreateRect(cv list("PC" "drawing") list(-0.530:-0.542 -0.510:0.000))
    shape = dbCreateRect(cv list("M1" "drawing") list(-0.592:0.400 -0.448:0.520))
    shape = dbCreateRect(cv list("M1" "drawing") list(-0.592:-0.520 -0.448:-0.400))
    shape = dbCreateRect(cv list("CB" "drawing") list(-0.540:0.440 -0.500:0.480))
    shape = dbCreateRect(cv list("CB" "drawing") list(-0.540:-0.480 -0.500:-0.440))
    shape = dbCreateRect(cv list("M1" "drawing") list(-0.384:-0.240 -0.344:-0.140))
    shape = dbCreateRect(cv list("M1" "drawing") list(-0.384:0.140 -0.344:0.240))
    shape = dbCreateRect(cv list("M1" "drawing") list(-0.488:-0.340 -0.448:-0.240))
    shape = dbCreateRect(cv list("M1" "drawing") list(-0.488:0.240 -0.448:0.340))
    shape = dbCreateRect(cv list("M1" "drawing") list(-0.426:-0.020 -0.406:0.020))
    shape = dbCreatePolygon(cv list("M1" "drawing") list(-0.364:0.140 -0.332:0.140 -0.332:-0.140 -0.364:-0.140 -0.364:-0.180 -0.292:-0.180 -0.292:0.180 -0.364:0.180))
    shape = dbCreateRect(cv list("CT" "drawing") list(-0.468:0.428 -0.364:0.492))
    shape = dbCreateRect(cv list("RVTP" "drawing") list(-0.618:0.000 -0.214:0.642))
    shape = dbCreateRect(cv list("NW" "drawing") list(-0.618:0.000 -0.214:0.642))
    shape = dbCreateRect(cv list("PPLUS" "drawing") list(-0.618:0.000 -0.214:0.642))
    shape = dbCreateRect(cv list("RX" "drawing") list(-0.518:0.140 -0.314:0.340))
    shape = dbCreateRect(cv list("PC" "drawing") list(-0.426:0.000 -0.406:0.542))
    shape = dbCreateRect(cv list("CT" "drawing") list(-0.468:-0.492 -0.364:-0.428))
    shape = dbCreateRect(cv list("LVTN" "drawing") list(-0.618:-0.642 -0.214:0.000))
    shape = dbCreateRect(cv list("NW" "drawing") list(-0.618:-0.642 -0.214:0.000))
    shape = dbCreateRect(cv list("NPLUS" "drawing") list(-0.618:-0.642 -0.214:0.000))
    shape = dbCreateRect(cv list("RX" "drawing") list(-0.518:-0.340 -0.314:-0.140))
    shape = dbCreateRect(cv list("PC" "drawing") list(-0.426:-0.542 -0.406:0.000))
    shape = dbCreateRect(cv list("M1" "drawing") list(-0.488:0.400 -0.344:0.520))
    shape = dbCreateRect(cv list("M1" "drawing") list(-0.488:-0.520 -0.344:-0.400))
    shape = dbCreateRect(cv list("CB" "drawing") list(-0.436:-0.020 -0.396:0.020))
    shape = dbCreateRect(cv list("CA" "drawing") list(-0.483:0.260 -0.453:0.320))
    shape = dbCreateRect(cv list("M1" "drawing") list(-0.488:0.340 -0.448:0.400))
    shape = dbCreateRect(cv list("CA" "drawing") list(-0.483:-0.320 -0.453:-0.260))
    shape = dbCreateRect(cv list("M1" "drawing") list(-0.488:-0.400 -0.448:-0.340))
    shape = dbCreateRect(cv list("CA" "drawing") list(-0.379:0.160 -0.349:0.220))
    shape = dbCreateRect(cv list("CA" "drawing") list(-0.379:-0.220 -0.349:-0.160))
    shape = dbCreateRect(cv list("M1" "drawing") list(-0.520:-0.020 -0.372:0.020))
    shape = dbCreateRect(cv list("CB" "drawing") list(-0.852:-0.480 -0.812:-0.440))
    shape = dbCreateRect(cv list("CB" "drawing") list(-0.852:0.440 -0.812:0.480))
    shape = dbCreateRect(cv list("M1" "drawing") list(-0.904:-0.520 -0.760:-0.400))
    shape = dbCreateRect(cv list("M1" "drawing") list(-0.904:0.400 -0.760:0.520))
    shape = dbCreateRect(cv list("PC" "drawing") list(-0.842:-0.542 -0.822:0.000))
    shape = dbCreateRect(cv list("RX" "drawing") list(-0.934:-0.340 -0.730:-0.140))
    shape = dbCreateRect(cv list("NPLUS" "drawing") list(-1.034:-0.642 -0.630:0.000))
    shape = dbCreateRect(cv list("NW" "drawing") list(-1.034:-0.642 -0.630:0.000))
    shape = dbCreateRect(cv list("LVTN" "drawing") list(-1.034:-0.642 -0.630:0.000))
    shape = dbCreateRect(cv list("CT" "drawing") list(-0.884:-0.032 -0.780:0.032))
    shape = dbCreateRect(cv list("PC" "drawing") list(-0.842:0.000 -0.822:0.542))
    shape = dbCreateRect(cv list("RX" "drawing") list(-0.934:0.140 -0.730:0.340))
    shape = dbCreateRect(cv list("PPLUS" "drawing") list(-1.034:0.000 -0.630:0.642))
    shape = dbCreateRect(cv list("NW" "drawing") list(-1.034:0.000 -0.630:0.642))
    shape = dbCreateRect(cv list("RVTP" "drawing") list(-1.034:0.000 -0.630:0.642))
    shape = dbCreateRect(cv list("CT" "drawing") list(-0.884:-0.032 -0.780:0.032))
    shape = dbCreateRect(cv list("M1" "drawing") list(-1.112:-0.340 -1.072:-0.240))
    shape = dbCreateRect(cv list("M1" "drawing") list(-1.112:0.240 -1.072:0.340))
    shape = dbCreateRect(cv list("M1" "drawing") list(-1.216:0.140 -1.176:0.240))
    shape = dbCreateRect(cv list("M1" "drawing") list(-1.320:-0.240 -1.280:-0.140))
    shape = dbCreateRect(cv list("M1" "drawing") list(-1.320:0.240 -1.280:0.340))
    shape = dbCreateRect(cv list("M1" "drawing") list(-1.154:0.060 -1.134:0.100))
    shape = dbCreateRect(cv list("M1" "drawing") list(-1.258:-0.100 -1.238:-0.060))
    shape = dbCreatePolygon(cv list("M1" "drawing") list(-1.300:-0.180 -1.020:-0.180 -1.020:0.180 -1.196:0.180 -1.196:0.140 -1.060:0.140 -1.060:-0.140 -1.300:-0.140))
    shape = dbCreateRect(cv list("M1" "drawing") list(-1.292:-0.100 -1.100:-0.060))
    shape = dbCreateRect(cv list("M1" "drawing") list(-1.292:0.060 -1.100:0.100))
    shape = dbCreateRect(cv list("CT" "drawing") list(-1.300:0.428 -1.092:0.492))
    shape = dbCreateRect(cv list("RVTP" "drawing") list(-1.450:0.000 -0.942:0.642))
    shape = dbCreateRect(cv list("NW" "drawing") list(-1.450:0.000 -0.942:0.642))
    shape = dbCreateRect(cv list("PPLUS" "drawing") list(-1.450:0.000 -0.942:0.642))
    shape = dbCreateRect(cv list("RX" "drawing") list(-1.350:0.140 -1.042:0.340))
    shape = dbCreateRect(cv list("PC" "drawing") list(-1.258:0.000 -1.238:0.542))
    shape = dbCreateRect(cv list("PC" "drawing") list(-1.154:0.000 -1.134:0.542))
    shape = dbCreateRect(cv list("CT" "drawing") list(-1.300:-0.492 -1.092:-0.428))
    shape = dbCreateRect(cv list("LVTN" "drawing") list(-1.450:-0.642 -0.942:0.000))
    shape = dbCreateRect(cv list("NW" "drawing") list(-1.450:-0.642 -0.942:0.000))
    shape = dbCreateRect(cv list("NPLUS" "drawing") list(-1.450:-0.642 -0.942:0.000))
    shape = dbCreateRect(cv list("RX" "drawing") list(-1.350:-0.340 -1.042:-0.140))
    shape = dbCreateRect(cv list("PC" "drawing") list(-1.258:-0.542 -1.238:0.000))
    shape = dbCreateRect(cv list("PC" "drawing") list(-1.154:-0.542 -1.134:0.000))
    shape = dbCreateRect(cv list("M1" "drawing") list(-1.320:0.400 -1.072:0.520))
    shape = dbCreateRect(cv list("M1" "drawing") list(-1.320:-0.520 -1.072:-0.400))
    shape = dbCreateRect(cv list("CB" "drawing") list(-1.268:-0.100 -1.228:-0.060))
    shape = dbCreateRect(cv list("CB" "drawing") list(-1.164:0.060 -1.124:0.100))
    shape = dbCreateRect(cv list("CA" "drawing") list(-1.315:0.260 -1.285:0.320))
    shape = dbCreateRect(cv list("M1" "drawing") list(-1.320:0.340 -1.280:0.400))
    shape = dbCreateRect(cv list("CA" "drawing") list(-1.315:-0.220 -1.285:-0.160))
    shape = dbCreateRect(cv list("CA" "drawing") list(-1.211:0.160 -1.181:0.220))
    shape = dbCreateRect(cv list("CA" "drawing") list(-1.107:0.260 -1.077:0.320))
    shape = dbCreateRect(cv list("M1" "drawing") list(-1.112:0.340 -1.072:0.400))
    shape = dbCreateRect(cv list("CA" "drawing") list(-1.107:-0.320 -1.077:-0.260))
    shape = dbCreateRect(cv list("M1" "drawing") list(-1.112:-0.400 -1.072:-0.340))
    shape = dbCreateRect(cv list("CT" "drawing") list(-1.092:-0.032 -0.988:0.032))
    shape = dbCreateRect(cv list("RVTP" "drawing") list(-1.242:0.000 -0.838:0.642))
    shape = dbCreateRect(cv list("NW" "drawing") list(-1.242:0.000 -0.838:0.642))
    shape = dbCreateRect(cv list("PPLUS" "drawing") list(-1.242:0.000 -0.838:0.642))
    shape = dbCreateRect(cv list("RX" "drawing") list(-1.142:0.140 -0.938:0.340))
    shape = dbCreateRect(cv list("PC" "drawing") list(-1.050:0.000 -1.030:0.542))
    shape = dbCreateRect(cv list("CT" "drawing") list(-1.092:-0.032 -0.988:0.032))
    shape = dbCreateRect(cv list("LVTN" "drawing") list(-1.242:-0.642 -0.838:0.000))
    shape = dbCreateRect(cv list("NW" "drawing") list(-1.242:-0.642 -0.838:0.000))
    shape = dbCreateRect(cv list("NPLUS" "drawing") list(-1.242:-0.642 -0.838:0.000))
    shape = dbCreateRect(cv list("RX" "drawing") list(-1.142:-0.340 -0.938:-0.140))
    shape = dbCreateRect(cv list("PC" "drawing") list(-1.050:-0.542 -1.030:0.000))
    shape = dbCreateRect(cv list("M1" "drawing") list(-1.112:0.400 -0.968:0.520))
    shape = dbCreateRect(cv list("M1" "drawing") list(-1.112:-0.520 -0.968:-0.400))
    shape = dbCreateRect(cv list("CB" "drawing") list(-1.060:0.440 -1.020:0.480))
    shape = dbCreateRect(cv list("CB" "drawing") list(-1.060:-0.480 -1.020:-0.440))
    shape = dbCreateRect(cv list("M1" "drawing") list(-0.904:-0.240 -0.864:-0.140))
    shape = dbCreateRect(cv list("M1" "drawing") list(-0.904:0.140 -0.864:0.240))
    shape = dbCreateRect(cv list("M1" "drawing") list(-1.008:-0.340 -0.968:-0.240))
    shape = dbCreateRect(cv list("M1" "drawing") list(-1.008:0.240 -0.968:0.340))
    shape = dbCreateRect(cv list("M1" "drawing") list(-0.946:-0.020 -0.926:0.020))
    shape = dbCreatePolygon(cv list("M1" "drawing") list(-0.884:0.140 -0.852:0.140 -0.852:-0.140 -0.884:-0.140 -0.884:-0.180 -0.812:-0.180 -0.812:0.180 -0.884:0.180))
    shape = dbCreateRect(cv list("CT" "drawing") list(-0.988:0.428 -0.884:0.492))
    shape = dbCreateRect(cv list("RVTP" "drawing") list(-1.138:0.000 -0.734:0.642))
    shape = dbCreateRect(cv list("NW" "drawing") list(-1.138:0.000 -0.734:0.642))
    shape = dbCreateRect(cv list("PPLUS" "drawing") list(-1.138:0.000 -0.734:0.642))
    shape = dbCreateRect(cv list("RX" "drawing") list(-1.038:0.140 -0.834:0.340))
    shape = dbCreateRect(cv list("PC" "drawing") list(-0.946:0.000 -0.926:0.542))
    shape = dbCreateRect(cv list("CT" "drawing") list(-0.988:-0.492 -0.884:-0.428))
    shape = dbCreateRect(cv list("LVTN" "drawing") list(-1.138:-0.642 -0.734:0.000))
    shape = dbCreateRect(cv list("NW" "drawing") list(-1.138:-0.642 -0.734:0.000))
    shape = dbCreateRect(cv list("NPLUS" "drawing") list(-1.138:-0.642 -0.734:0.000))
    shape = dbCreateRect(cv list("RX" "drawing") list(-1.038:-0.340 -0.834:-0.140))
    shape = dbCreateRect(cv list("PC" "drawing") list(-0.946:-0.542 -0.926:0.000))
    shape = dbCreateRect(cv list("M1" "drawing") list(-1.008:0.400 -0.864:0.520))
    shape = dbCreateRect(cv list("M1" "drawing") list(-1.008:-0.520 -0.864:-0.400))
    shape = dbCreateRect(cv list("CB" "drawing") list(-0.956:-0.020 -0.916:0.020))
    shape = dbCreateRect(cv list("CA" "drawing") list(-1.003:0.260 -0.973:0.320))
    shape = dbCreateRect(cv list("M1" "drawing") list(-1.008:0.340 -0.968:0.400))
    shape = dbCreateRect(cv list("CA" "drawing") list(-1.003:-0.320 -0.973:-0.260))
    shape = dbCreateRect(cv list("M1" "drawing") list(-1.008:-0.400 -0.968:-0.340))
    shape = dbCreateRect(cv list("CA" "drawing") list(-0.899:0.160 -0.869:0.220))
    shape = dbCreateRect(cv list("CA" "drawing") list(-0.899:-0.220 -0.869:-0.160))
    shape = dbCreateRect(cv list("M1" "drawing") list(-1.040:-0.020 -0.892:0.020))
    shape = dbCreateRect(cv list("CB" "drawing") list(-1.372:-0.480 -1.332:-0.440))
    shape = dbCreateRect(cv list("CB" "drawing") list(-1.372:0.440 -1.332:0.480))
    shape = dbCreateRect(cv list("M1" "drawing") list(-1.424:-0.520 -1.280:-0.400))
    shape = dbCreateRect(cv list("M1" "drawing") list(-1.424:0.400 -1.280:0.520))
    shape = dbCreateRect(cv list("PC" "drawing") list(-1.362:-0.542 -1.342:0.000))
    shape = dbCreateRect(cv list("RX" "drawing") list(-1.454:-0.340 -1.250:-0.140))
    shape = dbCreateRect(cv list("NPLUS" "drawing") list(-1.554:-0.642 -1.150:0.000))
    shape = dbCreateRect(cv list("NW" "drawing") list(-1.554:-0.642 -1.150:0.000))
    shape = dbCreateRect(cv list("LVTN" "drawing") list(-1.554:-0.642 -1.150:0.000))
    shape = dbCreateRect(cv list("CT" "drawing") list(-1.404:-0.032 -1.300:0.032))
    shape = dbCreateRect(cv list("PC" "drawing") list(-1.362:0.000 -1.342:0.542))
    shape = dbCreateRect(cv list("RX" "drawing") list(-1.454:0.140 -1.250:0.340))
    shape = dbCreateRect(cv list("PPLUS" "drawing") list(-1.554:0.000 -1.150:0.642))
    shape = dbCreateRect(cv list("NW" "drawing") list(-1.554:0.000 -1.150:0.642))
    shape = dbCreateRect(cv list("RVTP" "drawing") list(-1.554:0.000 -1.150:0.642))
    shape = dbCreateRect(cv list("CT" "drawing") list(-1.404:-0.032 -1.300:0.032))
    shape = dbCreateRect(cv list("M1" "drawing") list(-1.632:-0.340 -1.592:-0.240))
    shape = dbCreateRect(cv list("M1" "drawing") list(-1.632:0.240 -1.592:0.340))
    shape = dbCreateRect(cv list("M1" "drawing") list(-1.736:-0.240 -1.696:-0.140))
    shape = dbCreateRect(cv list("M1" "drawing") list(-1.840:-0.340 -1.800:-0.240))
    shape = dbCreateRect(cv list("M1" "drawing") list(-1.840:0.140 -1.800:0.240))
    shape = dbCreateRect(cv list("M1" "drawing") list(-1.674:0.060 -1.654:0.100))
    shape = dbCreateRect(cv list("M1" "drawing") list(-1.778:-0.100 -1.758:-0.060))
    shape = dbCreatePolygon(cv list("M1" "drawing") list(-1.820:0.140 -1.580:0.140 -1.580:-0.140 -1.716:-0.140 -1.716:-0.180 -1.540:-0.180 -1.540:0.180 -1.820:0.180))
    shape = dbCreateRect(cv list("M1" "drawing") list(-1.812:-0.100 -1.620:-0.060))
    shape = dbCreateRect(cv list("M1" "drawing") list(-1.812:0.060 -1.620:0.100))
    shape = dbCreateRect(cv list("CT" "drawing") list(-1.820:0.428 -1.612:0.492))
    shape = dbCreateRect(cv list("RVTP" "drawing") list(-1.970:0.000 -1.462:0.642))
    shape = dbCreateRect(cv list("NW" "drawing") list(-1.970:0.000 -1.462:0.642))
    shape = dbCreateRect(cv list("PPLUS" "drawing") list(-1.970:0.000 -1.462:0.642))
    shape = dbCreateRect(cv list("RX" "drawing") list(-1.870:0.140 -1.562:0.340))
    shape = dbCreateRect(cv list("PC" "drawing") list(-1.778:0.000 -1.758:0.542))
    shape = dbCreateRect(cv list("PC" "drawing") list(-1.674:0.000 -1.654:0.542))
    shape = dbCreateRect(cv list("CT" "drawing") list(-1.820:-0.492 -1.612:-0.428))
    shape = dbCreateRect(cv list("LVTN" "drawing") list(-1.970:-0.642 -1.462:0.000))
    shape = dbCreateRect(cv list("NW" "drawing") list(-1.970:-0.642 -1.462:0.000))
    shape = dbCreateRect(cv list("NPLUS" "drawing") list(-1.970:-0.642 -1.462:0.000))
    shape = dbCreateRect(cv list("RX" "drawing") list(-1.870:-0.340 -1.562:-0.140))
    shape = dbCreateRect(cv list("PC" "drawing") list(-1.778:-0.542 -1.758:0.000))
    shape = dbCreateRect(cv list("PC" "drawing") list(-1.674:-0.542 -1.654:0.000))
    shape = dbCreateRect(cv list("M1" "drawing") list(-1.840:0.400 -1.592:0.520))
    shape = dbCreateRect(cv list("M1" "drawing") list(-1.840:-0.520 -1.592:-0.400))
    shape = dbCreateRect(cv list("CB" "drawing") list(-1.788:-0.100 -1.748:-0.060))
    shape = dbCreateRect(cv list("CB" "drawing") list(-1.684:0.060 -1.644:0.100))
    shape = dbCreateRect(cv list("CA" "drawing") list(-1.835:0.160 -1.805:0.220))
    shape = dbCreateRect(cv list("CA" "drawing") list(-1.835:-0.320 -1.805:-0.260))
    shape = dbCreateRect(cv list("M1" "drawing") list(-1.840:-0.400 -1.800:-0.340))
    shape = dbCreateRect(cv list("CA" "drawing") list(-1.731:-0.220 -1.701:-0.160))
    shape = dbCreateRect(cv list("CA" "drawing") list(-1.627:0.260 -1.597:0.320))
    shape = dbCreateRect(cv list("M1" "drawing") list(-1.632:0.340 -1.592:0.400))
    shape = dbCreateRect(cv list("CA" "drawing") list(-1.627:-0.320 -1.597:-0.260))
    shape = dbCreateRect(cv list("M1" "drawing") list(-1.632:-0.400 -1.592:-0.340))
    shape = dbCreateRect(cv list("CT" "drawing") list(-1.612:-0.032 -1.508:0.032))
    shape = dbCreateRect(cv list("RVTP" "drawing") list(-1.762:0.000 -1.358:0.642))
    shape = dbCreateRect(cv list("NW" "drawing") list(-1.762:0.000 -1.358:0.642))
    shape = dbCreateRect(cv list("PPLUS" "drawing") list(-1.762:0.000 -1.358:0.642))
    shape = dbCreateRect(cv list("RX" "drawing") list(-1.662:0.140 -1.458:0.340))
    shape = dbCreateRect(cv list("PC" "drawing") list(-1.570:0.000 -1.550:0.542))
    shape = dbCreateRect(cv list("CT" "drawing") list(-1.612:-0.032 -1.508:0.032))
    shape = dbCreateRect(cv list("LVTN" "drawing") list(-1.762:-0.642 -1.358:0.000))
    shape = dbCreateRect(cv list("NW" "drawing") list(-1.762:-0.642 -1.358:0.000))
    shape = dbCreateRect(cv list("NPLUS" "drawing") list(-1.762:-0.642 -1.358:0.000))
    shape = dbCreateRect(cv list("RX" "drawing") list(-1.662:-0.340 -1.458:-0.140))
    shape = dbCreateRect(cv list("PC" "drawing") list(-1.570:-0.542 -1.550:0.000))
    shape = dbCreateRect(cv list("M1" "drawing") list(-1.632:0.400 -1.488:0.520))
    shape = dbCreateRect(cv list("M1" "drawing") list(-1.632:-0.520 -1.488:-0.400))
    shape = dbCreateRect(cv list("CB" "drawing") list(-1.580:0.440 -1.540:0.480))
    shape = dbCreateRect(cv list("CB" "drawing") list(-1.580:-0.480 -1.540:-0.440))
    shape = dbCreateRect(cv list("M1" "drawing") list(-1.424:-0.240 -1.384:-0.140))
    shape = dbCreateRect(cv list("M1" "drawing") list(-1.424:0.140 -1.384:0.240))
    shape = dbCreateRect(cv list("M1" "drawing") list(-1.528:-0.340 -1.488:-0.240))
    shape = dbCreateRect(cv list("M1" "drawing") list(-1.528:0.240 -1.488:0.340))
    shape = dbCreateRect(cv list("M1" "drawing") list(-1.466:-0.020 -1.446:0.020))
    shape = dbCreatePolygon(cv list("M1" "drawing") list(-1.404:0.140 -1.372:0.140 -1.372:-0.140 -1.404:-0.140 -1.404:-0.180 -1.332:-0.180 -1.332:0.180 -1.404:0.180))
    shape = dbCreateRect(cv list("CT" "drawing") list(-1.508:0.428 -1.404:0.492))
    shape = dbCreateRect(cv list("RVTP" "drawing") list(-1.658:0.000 -1.254:0.642))
    shape = dbCreateRect(cv list("NW" "drawing") list(-1.658:0.000 -1.254:0.642))
    shape = dbCreateRect(cv list("PPLUS" "drawing") list(-1.658:0.000 -1.254:0.642))
    shape = dbCreateRect(cv list("RX" "drawing") list(-1.558:0.140 -1.354:0.340))
    shape = dbCreateRect(cv list("PC" "drawing") list(-1.466:0.000 -1.446:0.542))
    shape = dbCreateRect(cv list("CT" "drawing") list(-1.508:-0.492 -1.404:-0.428))
    shape = dbCreateRect(cv list("LVTN" "drawing") list(-1.658:-0.642 -1.254:0.000))
    shape = dbCreateRect(cv list("NW" "drawing") list(-1.658:-0.642 -1.254:0.000))
    shape = dbCreateRect(cv list("NPLUS" "drawing") list(-1.658:-0.642 -1.254:0.000))
    shape = dbCreateRect(cv list("RX" "drawing") list(-1.558:-0.340 -1.354:-0.140))
    shape = dbCreateRect(cv list("PC" "drawing") list(-1.466:-0.542 -1.446:0.000))
    shape = dbCreateRect(cv list("M1" "drawing") list(-1.528:0.400 -1.384:0.520))
    shape = dbCreateRect(cv list("M1" "drawing") list(-1.528:-0.520 -1.384:-0.400))
    shape = dbCreateRect(cv list("CB" "drawing") list(-1.476:-0.020 -1.436:0.020))
    shape = dbCreateRect(cv list("CA" "drawing") list(-1.523:0.260 -1.493:0.320))
    shape = dbCreateRect(cv list("M1" "drawing") list(-1.528:0.340 -1.488:0.400))
    shape = dbCreateRect(cv list("CA" "drawing") list(-1.523:-0.320 -1.493:-0.260))
    shape = dbCreateRect(cv list("M1" "drawing") list(-1.528:-0.400 -1.488:-0.340))
    shape = dbCreateRect(cv list("CA" "drawing") list(-1.419:0.160 -1.389:0.220))
    shape = dbCreateRect(cv list("CA" "drawing") list(-1.419:-0.220 -1.389:-0.160))
    shape = dbCreateRect(cv list("M1" "drawing") list(-1.560:-0.020 -1.412:0.020))
    shape = dbCreateRect(cv list("CT" "drawing") list(-1.924:-0.032 -1.820:0.032))
    shape = dbCreateRect(cv list("RVTP" "drawing") list(-2.074:0.000 -1.670:0.642))
    shape = dbCreateRect(cv list("NW" "drawing") list(-2.074:0.000 -1.670:0.642))
    shape = dbCreateRect(cv list("PPLUS" "drawing") list(-2.074:0.000 -1.670:0.642))
    shape = dbCreateRect(cv list("RX" "drawing") list(-1.974:0.140 -1.770:0.340))
    shape = dbCreateRect(cv list("PC" "drawing") list(-1.882:0.000 -1.862:0.542))
    shape = dbCreateRect(cv list("CT" "drawing") list(-1.924:-0.032 -1.820:0.032))
    shape = dbCreateRect(cv list("LVTN" "drawing") list(-2.074:-0.642 -1.670:0.000))
    shape = dbCreateRect(cv list("NW" "drawing") list(-2.074:-0.642 -1.670:0.000))
    shape = dbCreateRect(cv list("NPLUS" "drawing") list(-2.074:-0.642 -1.670:0.000))
    shape = dbCreateRect(cv list("RX" "drawing") list(-1.974:-0.340 -1.770:-0.140))
    shape = dbCreateRect(cv list("PC" "drawing") list(-1.882:-0.542 -1.862:0.000))
    shape = dbCreateRect(cv list("M1" "drawing") list(-1.944:0.400 -1.800:0.520))
    shape = dbCreateRect(cv list("M1" "drawing") list(-1.944:-0.520 -1.800:-0.400))
    shape = dbCreateRect(cv list("CB" "drawing") list(-1.892:0.440 -1.852:0.480))
    shape = dbCreateRect(cv list("CB" "drawing") list(-1.892:-0.480 -1.852:-0.440))
    shape = dbCreateRect(cv list("M1" "drawing") list(-1.944:-0.240 -1.904:-0.140))
    shape = dbCreateRect(cv list("M1" "drawing") list(-1.944:0.140 -1.904:0.240))
    shape = dbCreateRect(cv list("M1" "drawing") list(-2.048:-0.340 -2.008:-0.240))
    shape = dbCreateRect(cv list("M1" "drawing") list(-2.048:0.240 -2.008:0.340))
    shape = dbCreateRect(cv list("M1" "drawing") list(-1.986:-0.020 -1.966:0.020))
    shape = dbCreatePolygon(cv list("M1" "drawing") list(-1.944:0.160 -1.944:-0.160 -1.904:-0.160 -1.904:0.160))
    shape = dbCreateRect(cv list("CT" "drawing") list(-2.028:0.428 -1.924:0.492))
    shape = dbCreateRect(cv list("RVTP" "drawing") list(-2.178:0.000 -1.774:0.642))
    shape = dbCreateRect(cv list("NW" "drawing") list(-2.178:0.000 -1.774:0.642))
    shape = dbCreateRect(cv list("PPLUS" "drawing") list(-2.178:0.000 -1.774:0.642))
    shape = dbCreateRect(cv list("RX" "drawing") list(-2.078:0.140 -1.874:0.340))
    shape = dbCreateRect(cv list("PC" "drawing") list(-1.986:0.000 -1.966:0.542))
    shape = dbCreateRect(cv list("CT" "drawing") list(-2.028:-0.492 -1.924:-0.428))
    shape = dbCreateRect(cv list("LVTN" "drawing") list(-2.178:-0.642 -1.774:0.000))
    shape = dbCreateRect(cv list("NW" "drawing") list(-2.178:-0.642 -1.774:0.000))
    shape = dbCreateRect(cv list("NPLUS" "drawing") list(-2.178:-0.642 -1.774:0.000))
    shape = dbCreateRect(cv list("RX" "drawing") list(-2.078:-0.340 -1.874:-0.140))
    shape = dbCreateRect(cv list("PC" "drawing") list(-1.986:-0.542 -1.966:0.000))
    shape = dbCreateRect(cv list("M1" "drawing") list(-2.048:0.400 -1.904:0.520))
    shape = dbCreateRect(cv list("M1" "drawing") list(-2.048:-0.520 -1.904:-0.400))
    shape = dbCreateRect(cv list("CB" "drawing") list(-1.996:-0.020 -1.956:0.020))
    shape = dbCreateRect(cv list("CA" "drawing") list(-2.043:0.260 -2.013:0.320))
    shape = dbCreateRect(cv list("M1" "drawing") list(-2.048:0.340 -2.008:0.400))
    shape = dbCreateRect(cv list("CA" "drawing") list(-2.043:-0.320 -2.013:-0.260))
    shape = dbCreateRect(cv list("M1" "drawing") list(-2.048:-0.400 -2.008:-0.340))
    shape = dbCreateRect(cv list("CA" "drawing") list(-1.939:0.160 -1.909:0.220))
    shape = dbCreateRect(cv list("CA" "drawing") list(-1.939:-0.220 -1.909:-0.160))
    shape = dbCreateRect(cv list("CT" "drawing") list(-2.132:-0.032 -2.028:0.032))
    shape = dbCreateRect(cv list("RVTP" "drawing") list(-2.282:0.000 -1.878:0.642))
    shape = dbCreateRect(cv list("NW" "drawing") list(-2.282:0.000 -1.878:0.642))
    shape = dbCreateRect(cv list("PPLUS" "drawing") list(-2.282:0.000 -1.878:0.642))
    shape = dbCreateRect(cv list("RX" "drawing") list(-2.182:0.140 -1.978:0.340))
    shape = dbCreateRect(cv list("PC" "drawing") list(-2.090:0.000 -2.070:0.542))
    shape = dbCreateRect(cv list("CT" "drawing") list(-2.132:-0.032 -2.028:0.032))
    shape = dbCreateRect(cv list("LVTN" "drawing") list(-2.282:-0.642 -1.878:0.000))
    shape = dbCreateRect(cv list("NW" "drawing") list(-2.282:-0.642 -1.878:0.000))
    shape = dbCreateRect(cv list("NPLUS" "drawing") list(-2.282:-0.642 -1.878:0.000))
    shape = dbCreateRect(cv list("RX" "drawing") list(-2.182:-0.340 -1.978:-0.140))
    shape = dbCreateRect(cv list("PC" "drawing") list(-2.090:-0.542 -2.070:0.000))
    shape = dbCreateRect(cv list("M1" "drawing") list(-2.152:0.400 -2.008:0.520))
    shape = dbCreateRect(cv list("M1" "drawing") list(-2.152:-0.520 -2.008:-0.400))
    shape = dbCreateRect(cv list("CB" "drawing") list(-2.100:0.440 -2.060:0.480))
    shape = dbCreateRect(cv list("CB" "drawing") list(-2.100:-0.480 -2.060:-0.440))
    shape = dbCreateRect(cv list("M1" "drawing") list(-2.288:-0.020 -2.140:0.020))
    shape = dbCreateRect(cv list("CA" "drawing") list(-2.147:-0.220 -2.117:-0.160))
    shape = dbCreateRect(cv list("CA" "drawing") list(-2.147:0.160 -2.117:0.220))
    shape = dbCreateRect(cv list("M1" "drawing") list(-2.256:-0.400 -2.216:-0.340))
    shape = dbCreateRect(cv list("CA" "drawing") list(-2.251:-0.320 -2.221:-0.260))
    shape = dbCreateRect(cv list("M1" "drawing") list(-2.256:0.340 -2.216:0.400))
    shape = dbCreateRect(cv list("CA" "drawing") list(-2.251:0.260 -2.221:0.320))
    shape = dbCreateRect(cv list("CB" "drawing") list(-2.204:-0.020 -2.164:0.020))
    shape = dbCreateRect(cv list("M1" "drawing") list(-2.256:-0.520 -2.112:-0.400))
    shape = dbCreateRect(cv list("M1" "drawing") list(-2.256:0.400 -2.112:0.520))
    shape = dbCreateRect(cv list("PC" "drawing") list(-2.194:-0.542 -2.174:0.000))
    shape = dbCreateRect(cv list("RX" "drawing") list(-2.286:-0.340 -2.082:-0.140))
    shape = dbCreateRect(cv list("NPLUS" "drawing") list(-2.386:-0.642 -1.982:0.000))
    shape = dbCreateRect(cv list("NW" "drawing") list(-2.386:-0.642 -1.982:0.000))
    shape = dbCreateRect(cv list("LVTN" "drawing") list(-2.386:-0.642 -1.982:0.000))
    shape = dbCreateRect(cv list("CT" "drawing") list(-2.236:-0.492 -2.132:-0.428))
    shape = dbCreateRect(cv list("PC" "drawing") list(-2.194:0.000 -2.174:0.542))
    shape = dbCreateRect(cv list("RX" "drawing") list(-2.286:0.140 -2.082:0.340))
    shape = dbCreateRect(cv list("PPLUS" "drawing") list(-2.386:0.000 -1.982:0.642))
    shape = dbCreateRect(cv list("NW" "drawing") list(-2.386:0.000 -1.982:0.642))
    shape = dbCreateRect(cv list("RVTP" "drawing") list(-2.386:0.000 -1.982:0.642))
    shape = dbCreateRect(cv list("CT" "drawing") list(-2.236:0.428 -2.132:0.492))
    shape = dbCreatePolygon(cv list("M1" "drawing") list(-2.132:0.140 -2.100:0.140 -2.100:-0.140 -2.132:-0.140 -2.132:-0.180 -2.060:-0.180 -2.060:0.180 -2.132:0.180))
    shape = dbCreateRect(cv list("M1" "drawing") list(-2.194:-0.020 -2.174:0.020))
    shape = dbCreateRect(cv list("M1" "drawing") list(-2.256:0.240 -2.216:0.340))
    shape = dbCreateRect(cv list("M1" "drawing") list(-2.256:-0.340 -2.216:-0.240))
    shape = dbCreateRect(cv list("M1" "drawing") list(-2.152:0.140 -2.112:0.240))
    shape = dbCreateRect(cv list("M1" "drawing") list(-2.152:-0.240 -2.112:-0.140))
    shape = dbCreateRect(cv list("CB" "drawing") list(-2.308:-0.480 -2.268:-0.440))
    shape = dbCreateRect(cv list("CB" "drawing") list(-2.308:0.440 -2.268:0.480))
    shape = dbCreateRect(cv list("M1" "drawing") list(-2.360:-0.520 -2.216:-0.400))
    shape = dbCreateRect(cv list("M1" "drawing") list(-2.360:0.400 -2.216:0.520))
    shape = dbCreateRect(cv list("PC" "drawing") list(-2.298:-0.542 -2.278:0.000))
    shape = dbCreateRect(cv list("RX" "drawing") list(-2.390:-0.340 -2.186:-0.140))
    shape = dbCreateRect(cv list("NPLUS" "drawing") list(-2.490:-0.642 -2.086:0.000))
    shape = dbCreateRect(cv list("NW" "drawing") list(-2.490:-0.642 -2.086:0.000))
    shape = dbCreateRect(cv list("LVTN" "drawing") list(-2.490:-0.642 -2.086:0.000))
    shape = dbCreateRect(cv list("CT" "drawing") list(-2.340:-0.032 -2.236:0.032))
    shape = dbCreateRect(cv list("PC" "drawing") list(-2.298:0.000 -2.278:0.542))
    shape = dbCreateRect(cv list("RX" "drawing") list(-2.390:0.140 -2.186:0.340))
    shape = dbCreateRect(cv list("PPLUS" "drawing") list(-2.490:0.000 -2.086:0.642))
    shape = dbCreateRect(cv list("NW" "drawing") list(-2.490:0.000 -2.086:0.642))
    shape = dbCreateRect(cv list("RVTP" "drawing") list(-2.490:0.000 -2.086:0.642))
    shape = dbCreateRect(cv list("CT" "drawing") list(-2.340:-0.032 -2.236:0.032))
    shape = dbCreateRect(cv list("M1" "drawing") list(-2.360:-0.400 -2.320:-0.340))
    shape = dbCreateRect(cv list("CA" "drawing") list(-2.355:-0.320 -2.325:-0.260))
    shape = dbCreateRect(cv list("M1" "drawing") list(-2.360:0.340 -2.320:0.400))
    shape = dbCreateRect(cv list("CA" "drawing") list(-2.355:0.260 -2.325:0.320))
    shape = dbCreateRect(cv list("CA" "drawing") list(-2.459:0.160 -2.429:0.220))
    shape = dbCreateRect(cv list("CA" "drawing") list(-2.563:-0.220 -2.533:-0.160))
    shape = dbCreateRect(cv list("M1" "drawing") list(-2.568:0.340 -2.528:0.400))
    shape = dbCreateRect(cv list("CA" "drawing") list(-2.563:0.260 -2.533:0.320))
    shape = dbCreateRect(cv list("CB" "drawing") list(-2.412:0.060 -2.372:0.100))
    shape = dbCreateRect(cv list("CB" "drawing") list(-2.516:-0.100 -2.476:-0.060))
    shape = dbCreateRect(cv list("M1" "drawing") list(-2.568:-0.520 -2.320:-0.400))
    shape = dbCreateRect(cv list("M1" "drawing") list(-2.568:0.400 -2.320:0.520))
    shape = dbCreateRect(cv list("PC" "drawing") list(-2.402:-0.542 -2.382:0.000))
    shape = dbCreateRect(cv list("PC" "drawing") list(-2.506:-0.542 -2.486:0.000))
    shape = dbCreateRect(cv list("RX" "drawing") list(-2.598:-0.340 -2.290:-0.140))
    shape = dbCreateRect(cv list("NPLUS" "drawing") list(-2.698:-0.642 -2.190:0.000))
    shape = dbCreateRect(cv list("NW" "drawing") list(-2.698:-0.642 -2.190:0.000))
    shape = dbCreateRect(cv list("LVTN" "drawing") list(-2.698:-0.642 -2.190:0.000))
    shape = dbCreateRect(cv list("CT" "drawing") list(-2.548:-0.492 -2.340:-0.428))
    shape = dbCreateRect(cv list("PC" "drawing") list(-2.402:0.000 -2.382:0.542))
    shape = dbCreateRect(cv list("PC" "drawing") list(-2.506:0.000 -2.486:0.542))
    shape = dbCreateRect(cv list("RX" "drawing") list(-2.598:0.140 -2.290:0.340))
    shape = dbCreateRect(cv list("PPLUS" "drawing") list(-2.698:0.000 -2.190:0.642))
    shape = dbCreateRect(cv list("NW" "drawing") list(-2.698:0.000 -2.190:0.642))
    shape = dbCreateRect(cv list("RVTP" "drawing") list(-2.698:0.000 -2.190:0.642))
    shape = dbCreateRect(cv list("CT" "drawing") list(-2.548:0.428 -2.340:0.492))
    shape = dbCreateRect(cv list("M1" "drawing") list(-2.540:0.060 -2.348:0.100))
    shape = dbCreateRect(cv list("M1" "drawing") list(-2.540:-0.100 -2.348:-0.060))
    shape = dbCreatePolygon(cv list("M1" "drawing") list(-2.548:-0.180 -2.268:-0.180 -2.268:0.180 -2.444:0.180 -2.444:0.140 -2.308:0.140 -2.308:-0.140 -2.548:-0.140))
    shape = dbCreateRect(cv list("M1" "drawing") list(-2.506:-0.100 -2.486:-0.060))
    shape = dbCreateRect(cv list("M1" "drawing") list(-2.402:0.060 -2.382:0.100))
    shape = dbCreateRect(cv list("M1" "drawing") list(-2.568:0.240 -2.528:0.340))
    shape = dbCreateRect(cv list("M1" "drawing") list(-2.568:-0.240 -2.528:-0.140))
    shape = dbCreateRect(cv list("M1" "drawing") list(-2.464:0.140 -2.424:0.240))
    shape = dbCreateRect(cv list("M1" "drawing") list(-2.360:0.240 -2.320:0.340))
    shape = dbCreateRect(cv list("M1" "drawing") list(-2.360:-0.340 -2.320:-0.240))
    shape = dbCreateRect(cv list("M2" "drawing") list(-0.010:0.860 0.010:0.820))
    shape = dbCreateRect(cv list("M1" "drawing") list(-0.010:0.860 0.010:0.820))
    shape = dbCreateRect(cv list("M2" "drawing") list(0.104:0.940 0.252:0.900))
    shape = dbCreateRect(cv list("M1" "drawing") list(0.104:0.940 0.252:0.900))
    shape = dbCreateRect(cv list("M2" "drawing") list(0.198:1.100 0.322:1.060))
    shape = dbCreateRect(cv list("M1" "drawing") list(0.198:1.100 0.322:1.060))
    shape = dbCreateRect(cv list("V1" "drawing") list(0.220:1.100 0.300:1.060))
    shape = dbCreateRect(cv list("V1" "drawing") list(0.138:0.940 0.218:0.900))
    shape = dbCreateRect(cv list("V1" "drawing") list(0.629:1.020 0.709:0.980))
    shape = dbCreateRect(cv list("V1" "drawing") list(0.435:1.020 0.515:0.980))
    shape = dbCreateRect(cv list("V1" "drawing") list(1.572:0.940 1.652:0.900))
    shape = dbCreateRect(cv list("V1" "drawing") list(1.624:1.020 1.704:0.980))
    shape = dbCreateRect(cv list("V1" "drawing") list(0.948:0.860 1.028:0.820))
    shape = dbCreateRect(cv list("V1" "drawing") list(0.948:1.020 1.028:0.980))
    shape = dbCreateRect(cv list("V1" "drawing") list(1.260:0.860 1.340:0.820))
    shape = dbCreateRect(cv list("V1" "drawing") list(1.260:1.020 1.340:0.980))
    shape = dbCreateRect(cv list("V1" "drawing") list(0.629:0.860 0.709:0.820))
    shape = dbCreateRect(cv list("V1" "drawing") list(0.435:0.860 0.515:0.820))
    shape = dbCreateRect(cv list("V1" "drawing") list(-0.040:0.860 0.040:0.820))
    shape = dbCreateRect(cv list("M1" "drawing") list(1.840:0.940 1.976:0.900))
    shape = dbCreateRect(cv list("M2" "drawing") list(0.000:0.820 0.668:0.860))
    shape = dbCreateRect(cv list("M1" "drawing") list(0.372:0.860 0.772:0.820))
    shape = dbCreateRect(cv list("M1" "drawing") list(1.204:1.020 1.396:0.980))
    shape = dbCreateRect(cv list("M1" "drawing") list(1.204:0.860 1.396:0.820))
    shape = dbCreateRect(cv list("M1" "drawing") list(0.892:1.020 1.084:0.980))
    shape = dbCreateRect(cv list("M1" "drawing") list(0.892:0.860 1.084:0.820))
    shape = dbCreateRect(cv list("M1" "drawing") list(1.560:1.020 1.768:0.980))
    shape = dbCreatePolygon(cv list("M1" "drawing") list(1.644:0.920 1.644:0.820 1.768:0.820 1.768:0.860 1.684:0.860 1.684:0.920))
    shape = dbCreateRect(cv list("M1" "drawing") list(1.528:0.940 1.696:0.900))
    shape = dbCreateRect(cv list("M1" "drawing") list(0.372:1.020 0.772:0.980))
    shape = dbCreateRect(cv list("M1" "drawing") list(0.312:0.940 0.772:0.900))
    shape = dbCreatePolygon(cv list("M2" "drawing") list(0.104:0.900 0.332:0.900 0.332:0.980 0.812:0.980 0.812:0.820 1.788:0.820 1.788:1.020 1.560:1.020 1.560:0.980 1.748:0.980 1.748:0.860 0.852:0.860 0.852:1.020 0.292:1.020 0.292:0.940 0.104:0.940))
    shape = dbCreatePolygon(cv list("M2" "drawing") list(0.260:1.060 0.916:1.060 0.916:0.980 1.436:0.980 1.436:0.900 1.664:0.900 1.664:0.940 1.476:0.940 1.476:1.020 0.956:1.020 0.956:1.100 0.260:1.100))
    shape = dbCreateRect(cv list("M1" "drawing") list(1.456:0.860 1.614:0.820))
    shape = dbCreatePolygon(cv list("M1" "drawing") list(1.612:1.220 1.800:1.220 1.800:1.060 1.852:1.060 1.852:0.920 1.892:0.920 1.892:1.100 1.840:1.100 1.840:1.260 1.612:1.260))
    shape = dbCreatePolygon(cv list("M1" "drawing") list(1.612:0.580 1.840:0.580 1.840:0.740 1.892:0.740 1.892:0.920 1.852:0.920 1.852:0.780 1.800:0.780 1.800:0.620 1.612:0.620))
    shape = dbCreatePolygon(cv list("M1" "drawing") list(0.884:1.190 1.072:1.190 1.072:1.060 1.124:1.060 1.124:0.920 1.164:0.920 1.164:1.100 1.112:1.100 1.112:1.230 0.884:1.230))
    shape = dbCreatePolygon(cv list("M1" "drawing") list(0.884:0.610 1.112:0.610 1.112:0.740 1.164:0.740 1.164:0.920 1.124:0.920 1.124:0.780 1.072:0.780 1.072:0.650 0.884:0.650))
    shape = dbCreateRect(cv list("M1" "drawing") list(2.080:0.900 2.184:0.940))
    shape = dbCreateRect(cv list("CA" "drawing") list(2.221:1.140 2.251:1.080))
    shape = dbCreateRect(cv list("CA" "drawing") list(2.221:0.760 2.251:0.700))
    shape = dbCreateRect(cv list("M1" "drawing") list(2.112:1.320 2.152:1.260))
    shape = dbCreateRect(cv list("CA" "drawing") list(2.117:1.240 2.147:1.180))
    shape = dbCreateRect(cv list("M1" "drawing") list(2.112:0.580 2.152:0.520))
    shape = dbCreateRect(cv list("CA" "drawing") list(2.117:0.660 2.147:0.600))
    shape = dbCreateRect(cv list("CB" "drawing") list(2.164:0.940 2.204:0.900))
    shape = dbCreateRect(cv list("M1" "drawing") list(2.112:1.440 2.256:1.320))
    shape = dbCreateRect(cv list("M1" "drawing") list(2.112:0.520 2.256:0.400))
    shape = dbCreateRect(cv list("PC" "drawing") list(2.174:1.462 2.194:0.920))
    shape = dbCreateRect(cv list("RX" "drawing") list(2.082:1.260 2.286:1.060))
    shape = dbCreateRect(cv list("NPLUS" "drawing") list(1.982:1.562 2.386:0.920))
    shape = dbCreateRect(cv list("NW" "drawing") list(1.982:1.562 2.386:0.920))
    shape = dbCreateRect(cv list("LVTN" "drawing") list(1.982:1.562 2.386:0.920))
    shape = dbCreateRect(cv list("CT" "drawing") list(2.132:1.412 2.236:1.348))
    shape = dbCreateRect(cv list("PC" "drawing") list(2.174:0.920 2.194:0.378))
    shape = dbCreateRect(cv list("RX" "drawing") list(2.082:0.780 2.286:0.580))
    shape = dbCreateRect(cv list("PPLUS" "drawing") list(1.982:0.920 2.386:0.278))
    shape = dbCreateRect(cv list("NW" "drawing") list(1.982:0.920 2.386:0.278))
    shape = dbCreateRect(cv list("RVTP" "drawing") list(1.982:0.920 2.386:0.278))
    shape = dbCreateRect(cv list("CT" "drawing") list(2.132:0.492 2.236:0.428))
    shape = dbCreatePolygon(cv list("M1" "drawing") list(2.236:0.740 2.308:0.740 2.308:1.100 2.236:1.100 2.236:1.060 2.268:1.060 2.268:0.780 2.236:0.780))
    shape = dbCreateRect(cv list("M1" "drawing") list(2.174:0.940 2.194:0.900))
    shape = dbCreateRect(cv list("M1" "drawing") list(2.112:0.680 2.152:0.580))
    shape = dbCreateRect(cv list("M1" "drawing") list(2.112:1.260 2.152:1.160))
    shape = dbCreateRect(cv list("M1" "drawing") list(2.216:0.780 2.256:0.680))
    shape = dbCreateRect(cv list("M1" "drawing") list(2.216:1.160 2.256:1.060))
    shape = dbCreateRect(cv list("CA" "drawing") list(2.013:1.140 2.043:1.080))
    shape = dbCreateRect(cv list("CA" "drawing") list(2.013:0.760 2.043:0.700))
    shape = dbCreateRect(cv list("M1" "drawing") list(1.904:1.320 1.944:1.260))
    shape = dbCreateRect(cv list("CA" "drawing") list(1.909:1.240 1.939:1.180))
    shape = dbCreateRect(cv list("M1" "drawing") list(1.904:0.580 1.944:0.520))
    shape = dbCreateRect(cv list("CA" "drawing") list(1.909:0.660 1.939:0.600))
    shape = dbCreateRect(cv list("M1" "drawing") list(2.112:1.320 2.152:1.260))
    shape = dbCreateRect(cv list("M1" "drawing") list(2.112:0.580 2.152:0.520))
    shape = dbCreateRect(cv list("CA" "drawing") list(2.117:1.240 2.147:1.180))
    shape = dbCreateRect(cv list("CA" "drawing") list(2.117:0.660 2.147:0.600))
    shape = dbCreateRect(cv list("CB" "drawing") list(2.060:1.400 2.100:1.360))
    shape = dbCreateRect(cv list("CB" "drawing") list(2.060:0.480 2.100:0.440))
    shape = dbCreateRect(cv list("CB" "drawing") list(1.956:0.940 1.996:0.900))
    shape = dbCreateRect(cv list("M1" "drawing") list(1.904:1.440 2.152:1.320))
    shape = dbCreateRect(cv list("M1" "drawing") list(1.904:0.520 2.152:0.400))
    shape = dbCreateRect(cv list("PC" "drawing") list(2.070:1.462 2.090:0.920))
    shape = dbCreateRect(cv list("RX" "drawing") list(1.978:1.260 2.182:1.060))
    shape = dbCreateRect(cv list("NPLUS" "drawing") list(1.878:1.562 2.282:0.920))
    shape = dbCreateRect(cv list("NW" "drawing") list(1.878:1.562 2.282:0.920))
    shape = dbCreateRect(cv list("LVTN" "drawing") list(1.878:1.562 2.282:0.920))
    shape = dbCreateRect(cv list("CT" "drawing") list(2.028:0.952 2.132:0.888))
    shape = dbCreateRect(cv list("PC" "drawing") list(1.966:1.462 1.986:0.920))
    shape = dbCreateRect(cv list("RX" "drawing") list(1.874:1.260 2.078:1.060))
    shape = dbCreateRect(cv list("NPLUS" "drawing") list(1.774:1.562 2.178:0.920))
    shape = dbCreateRect(cv list("NW" "drawing") list(1.774:1.562 2.178:0.920))
    shape = dbCreateRect(cv list("LVTN" "drawing") list(1.774:1.562 2.178:0.920))
    shape = dbCreateRect(cv list("CT" "drawing") list(1.924:1.412 2.028:1.348))
    shape = dbCreateRect(cv list("PC" "drawing") list(2.070:0.920 2.090:0.378))
    shape = dbCreateRect(cv list("RX" "drawing") list(1.978:0.780 2.182:0.580))
    shape = dbCreateRect(cv list("PPLUS" "drawing") list(1.878:0.920 2.282:0.278))
    shape = dbCreateRect(cv list("NW" "drawing") list(1.878:0.920 2.282:0.278))
    shape = dbCreateRect(cv list("RVTP" "drawing") list(1.878:0.920 2.282:0.278))
    shape = dbCreateRect(cv list("CT" "drawing") list(2.028:0.952 2.132:0.888))
    shape = dbCreateRect(cv list("PC" "drawing") list(1.966:0.920 1.986:0.378))
    shape = dbCreateRect(cv list("RX" "drawing") list(1.874:0.780 2.078:0.580))
    shape = dbCreateRect(cv list("PPLUS" "drawing") list(1.774:0.920 2.178:0.278))
    shape = dbCreateRect(cv list("NW" "drawing") list(1.774:0.920 2.178:0.278))
    shape = dbCreateRect(cv list("RVTP" "drawing") list(1.774:0.920 2.178:0.278))
    shape = dbCreateRect(cv list("CT" "drawing") list(1.924:0.492 2.028:0.428))
    shape = dbCreatePolygon(cv list("M1" "drawing") list(2.028:0.740 2.100:0.740 2.100:1.100 2.028:1.100 2.028:1.060 2.060:1.060 2.060:0.780 2.028:0.780))
    shape = dbCreateRect(cv list("M1" "drawing") list(1.966:0.940 1.986:0.900))
    shape = dbCreateRect(cv list("M1" "drawing") list(2.112:0.680 2.152:0.580))
    shape = dbCreateRect(cv list("M1" "drawing") list(2.112:1.260 2.152:1.160))
    shape = dbCreateRect(cv list("M1" "drawing") list(1.904:0.680 1.944:0.580))
    shape = dbCreateRect(cv list("M1" "drawing") list(1.904:1.260 1.944:1.160))
    shape = dbCreateRect(cv list("M1" "drawing") list(2.008:0.780 2.048:0.680))
    shape = dbCreateRect(cv list("M1" "drawing") list(2.008:1.160 2.048:1.060))
    shape = dbCreateRect(cv list("CA" "drawing") list(1.701:1.140 1.731:1.080))
    shape = dbCreateRect(cv list("CA" "drawing") list(1.701:0.760 1.731:0.700))
    shape = dbCreateRect(cv list("M1" "drawing") list(1.904:1.320 1.944:1.260))
    shape = dbCreateRect(cv list("CA" "drawing") list(1.909:1.240 1.939:1.180))
    shape = dbCreateRect(cv list("M1" "drawing") list(1.904:0.580 1.944:0.520))
    shape = dbCreateRect(cv list("CA" "drawing") list(1.909:0.660 1.939:0.600))
    shape = dbCreateRect(cv list("PC" "drawing") list(1.758:1.380 1.778:0.920))
    shape = dbCreateRect(cv list("RX" "drawing") list(1.666:1.260 1.870:1.060))
    shape = dbCreateRect(cv list("NPLUS" "drawing") list(1.566:1.480 1.970:0.920))
    shape = dbCreateRect(cv list("NW" "drawing") list(1.566:1.480 1.970:0.920))
    shape = dbCreateRect(cv list("LVTN" "drawing") list(1.566:1.480 1.970:0.920))
    shape = dbCreateRect(cv list("CT" "drawing") list(1.716:0.952 1.820:0.888))
    shape = dbCreateRect(cv list("PC" "drawing") list(1.758:0.920 1.778:0.460))
    shape = dbCreateRect(cv list("RX" "drawing") list(1.666:0.780 1.870:0.580))
    shape = dbCreateRect(cv list("PPLUS" "drawing") list(1.566:0.920 1.970:0.360))
    shape = dbCreateRect(cv list("NW" "drawing") list(1.566:0.920 1.970:0.360))
    shape = dbCreateRect(cv list("RVTP" "drawing") list(1.566:0.920 1.970:0.360))
    shape = dbCreateRect(cv list("CT" "drawing") list(1.716:0.952 1.820:0.888))
    shape = dbCreateRect(cv list("CB" "drawing") list(1.748:1.020 1.788:0.980))
    shape = dbCreateRect(cv list("CB" "drawing") list(1.748:0.860 1.788:0.820))
    shape = dbCreateRect(cv list("CB" "drawing") list(1.852:0.940 1.892:0.900))
    shape = dbCreateRect(cv list("M1" "drawing") list(1.696:1.440 1.944:1.320))
    shape = dbCreateRect(cv list("M1" "drawing") list(1.696:0.520 1.944:0.400))
    shape = dbCreateRect(cv list("PC" "drawing") list(1.758:1.462 1.778:0.920))
    shape = dbCreateRect(cv list("PC" "drawing") list(1.862:1.462 1.882:0.920))
    shape = dbCreateRect(cv list("RX" "drawing") list(1.666:1.260 1.974:1.060))
    shape = dbCreateRect(cv list("NPLUS" "drawing") list(1.566:1.562 2.074:0.920))
    shape = dbCreateRect(cv list("NW" "drawing") list(1.566:1.562 2.074:0.920))
    shape = dbCreateRect(cv list("LVTN" "drawing") list(1.566:1.562 2.074:0.920))
    shape = dbCreateRect(cv list("CT" "drawing") list(1.716:1.412 1.924:1.348))
    shape = dbCreateRect(cv list("PC" "drawing") list(1.758:0.920 1.778:0.378))
    shape = dbCreateRect(cv list("PC" "drawing") list(1.862:0.920 1.882:0.378))
    shape = dbCreateRect(cv list("RX" "drawing") list(1.666:0.780 1.974:0.580))
    shape = dbCreateRect(cv list("PPLUS" "drawing") list(1.566:0.920 2.074:0.278))
    shape = dbCreateRect(cv list("NW" "drawing") list(1.566:0.920 2.074:0.278))
    shape = dbCreateRect(cv list("RVTP" "drawing") list(1.566:0.920 2.074:0.278))
    shape = dbCreateRect(cv list("CT" "drawing") list(1.716:0.492 1.924:0.428))
    shape = dbCreatePolygon(cv list("M1" "drawing") list(1.716:0.780 1.476:0.780 1.476:1.060 1.716:1.060 1.716:1.100 1.436:1.100 1.436:0.740 1.716:0.740))
    shape = dbCreateRect(cv list("M1" "drawing") list(1.862:0.940 1.882:0.900))
    shape = dbCreateRect(cv list("M1" "drawing") list(1.758:0.860 1.778:0.820))
    shape = dbCreateRect(cv list("M1" "drawing") list(1.758:1.020 1.778:0.980))
    shape = dbCreateRect(cv list("M1" "drawing") list(1.904:0.680 1.944:0.580))
    shape = dbCreateRect(cv list("M1" "drawing") list(1.904:1.260 1.944:1.160))
    shape = dbCreateRect(cv list("M1" "drawing") list(1.696:0.780 1.736:0.680))
    shape = dbCreateRect(cv list("M1" "drawing") list(1.696:1.160 1.736:1.060))
    shape = dbCreateRect(cv list("CB" "drawing") list(1.644:1.400 1.684:1.360))
    shape = dbCreateRect(cv list("CB" "drawing") list(1.644:0.480 1.684:0.440))
    shape = dbCreateRect(cv list("M1" "drawing") list(1.592:1.440 1.736:1.320))
    shape = dbCreateRect(cv list("M1" "drawing") list(1.592:0.520 1.736:0.400))
    shape = dbCreateRect(cv list("PC" "drawing") list(1.654:1.462 1.674:0.920))
    shape = dbCreateRect(cv list("RX" "drawing") list(1.562:1.260 1.766:1.060))
    shape = dbCreateRect(cv list("NPLUS" "drawing") list(1.462:1.562 1.866:0.920))
    shape = dbCreateRect(cv list("NW" "drawing") list(1.462:1.562 1.866:0.920))
    shape = dbCreateRect(cv list("LVTN" "drawing") list(1.462:1.562 1.866:0.920))
    shape = dbCreateRect(cv list("CT" "drawing") list(1.612:0.952 1.716:0.888))
    shape = dbCreateRect(cv list("PC" "drawing") list(1.654:0.920 1.674:0.378))
    shape = dbCreateRect(cv list("RX" "drawing") list(1.562:0.780 1.766:0.580))
    shape = dbCreateRect(cv list("PPLUS" "drawing") list(1.462:0.920 1.866:0.278))
    shape = dbCreateRect(cv list("NW" "drawing") list(1.462:0.920 1.866:0.278))
    shape = dbCreateRect(cv list("RVTP" "drawing") list(1.462:0.920 1.866:0.278))
    shape = dbCreateRect(cv list("CT" "drawing") list(1.612:0.952 1.716:0.888))
    shape = dbCreateRect(cv list("CA" "drawing") list(1.597:1.240 1.627:1.180))
    shape = dbCreateRect(cv list("CA" "drawing") list(1.597:0.660 1.627:0.600))
    shape = dbCreateRect(cv list("M1" "drawing") list(1.488:1.320 1.528:1.260))
    shape = dbCreateRect(cv list("CA" "drawing") list(1.493:1.240 1.523:1.180))
    shape = dbCreateRect(cv list("M1" "drawing") list(1.488:0.580 1.528:0.520))
    shape = dbCreateRect(cv list("CA" "drawing") list(1.493:0.660 1.523:0.600))
    shape = dbCreateRect(cv list("CB" "drawing") list(1.540:0.860 1.580:0.820))
    shape = dbCreateRect(cv list("M1" "drawing") list(1.488:1.440 1.632:1.320))
    shape = dbCreateRect(cv list("M1" "drawing") list(1.488:0.520 1.632:0.400))
    shape = dbCreateRect(cv list("PC" "drawing") list(1.550:1.462 1.570:0.920))
    shape = dbCreateRect(cv list("RX" "drawing") list(1.458:1.260 1.662:1.060))
    shape = dbCreateRect(cv list("NPLUS" "drawing") list(1.358:1.562 1.762:0.920))
    shape = dbCreateRect(cv list("NW" "drawing") list(1.358:1.562 1.762:0.920))
    shape = dbCreateRect(cv list("LVTN" "drawing") list(1.358:1.562 1.762:0.920))
    shape = dbCreateRect(cv list("CT" "drawing") list(1.508:1.412 1.612:1.348))
    shape = dbCreateRect(cv list("PC" "drawing") list(1.550:0.920 1.570:0.378))
    shape = dbCreateRect(cv list("RX" "drawing") list(1.458:0.780 1.662:0.580))
    shape = dbCreateRect(cv list("PPLUS" "drawing") list(1.358:0.920 1.762:0.278))
    shape = dbCreateRect(cv list("NW" "drawing") list(1.358:0.920 1.762:0.278))
    shape = dbCreateRect(cv list("RVTP" "drawing") list(1.358:0.920 1.762:0.278))
    shape = dbCreateRect(cv list("CT" "drawing") list(1.508:0.492 1.612:0.428))
    shape = dbCreateRect(cv list("M1" "drawing") list(1.550:0.860 1.570:0.820))
    shape = dbCreateRect(cv list("M1" "drawing") list(1.488:0.680 1.528:0.580))
    shape = dbCreateRect(cv list("M1" "drawing") list(1.488:1.260 1.528:1.160))
    shape = dbCreateRect(cv list("M1" "drawing") list(1.592:0.680 1.632:0.580))
    shape = dbCreateRect(cv list("M1" "drawing") list(1.592:1.260 1.632:1.160))
    shape = dbCreateRect(cv list("CA" "drawing") list(1.389:1.140 1.419:1.080))
    shape = dbCreateRect(cv list("CA" "drawing") list(1.389:0.760 1.419:0.700))
    shape = dbCreateRect(cv list("CA" "drawing") list(1.285:1.240 1.315:1.180))
    shape = dbCreateRect(cv list("CA" "drawing") list(1.285:0.660 1.315:0.600))
    shape = dbCreateRect(cv list("M1" "drawing") list(1.488:1.320 1.528:1.260))
    shape = dbCreateRect(cv list("M1" "drawing") list(1.488:0.580 1.528:0.520))
    shape = dbCreateRect(cv list("CA" "drawing") list(1.493:1.240 1.523:1.180))
    shape = dbCreateRect(cv list("CA" "drawing") list(1.493:0.660 1.523:0.600))
    shape = dbCreateRect(cv list("CB" "drawing") list(1.436:1.400 1.476:1.360))
    shape = dbCreateRect(cv list("CB" "drawing") list(1.436:0.480 1.476:0.440))
    shape = dbCreateRect(cv list("PC" "drawing") list(1.342:1.380 1.362:0.920))
    shape = dbCreateRect(cv list("RX" "drawing") list(1.250:1.260 1.454:1.060))
    shape = dbCreateRect(cv list("NPLUS" "drawing") list(1.150:1.480 1.554:0.920))
    shape = dbCreateRect(cv list("NW" "drawing") list(1.150:1.480 1.554:0.920))
    shape = dbCreateRect(cv list("LVTN" "drawing") list(1.150:1.480 1.554:0.920))
    shape = dbCreateRect(cv list("CT" "drawing") list(1.300:0.952 1.404:0.888))
    shape = dbCreateRect(cv list("PC" "drawing") list(1.342:0.920 1.362:0.460))
    shape = dbCreateRect(cv list("RX" "drawing") list(1.250:0.780 1.454:0.580))
    shape = dbCreateRect(cv list("PPLUS" "drawing") list(1.150:0.920 1.554:0.360))
    shape = dbCreateRect(cv list("NW" "drawing") list(1.150:0.920 1.554:0.360))
    shape = dbCreateRect(cv list("RVTP" "drawing") list(1.150:0.920 1.554:0.360))
    shape = dbCreateRect(cv list("CT" "drawing") list(1.300:0.952 1.404:0.888))
    shape = dbCreateRect(cv list("CB" "drawing") list(1.332:1.020 1.372:0.980))
    shape = dbCreateRect(cv list("CB" "drawing") list(1.332:0.860 1.372:0.820))
    shape = dbCreateRect(cv list("M1" "drawing") list(1.280:1.440 1.528:1.320))
    shape = dbCreateRect(cv list("M1" "drawing") list(1.280:0.520 1.528:0.400))
    shape = dbCreateRect(cv list("PC" "drawing") list(1.446:1.462 1.466:0.920))
    shape = dbCreateRect(cv list("RX" "drawing") list(1.354:1.260 1.558:1.060))
    shape = dbCreateRect(cv list("NPLUS" "drawing") list(1.254:1.562 1.658:0.920))
    shape = dbCreateRect(cv list("NW" "drawing") list(1.254:1.562 1.658:0.920))
    shape = dbCreateRect(cv list("LVTN" "drawing") list(1.254:1.562 1.658:0.920))
    shape = dbCreateRect(cv list("CT" "drawing") list(1.404:0.952 1.508:0.888))
    shape = dbCreateRect(cv list("PC" "drawing") list(1.342:1.462 1.362:0.920))
    shape = dbCreateRect(cv list("RX" "drawing") list(1.250:1.260 1.454:1.060))
    shape = dbCreateRect(cv list("NPLUS" "drawing") list(1.150:1.562 1.554:0.920))
    shape = dbCreateRect(cv list("NW" "drawing") list(1.150:1.562 1.554:0.920))
    shape = dbCreateRect(cv list("LVTN" "drawing") list(1.150:1.562 1.554:0.920))
    shape = dbCreateRect(cv list("CT" "drawing") list(1.300:1.412 1.404:1.348))
    shape = dbCreateRect(cv list("PC" "drawing") list(1.446:0.920 1.466:0.378))
    shape = dbCreateRect(cv list("RX" "drawing") list(1.354:0.780 1.558:0.580))
    shape = dbCreateRect(cv list("PPLUS" "drawing") list(1.254:0.920 1.658:0.278))
    shape = dbCreateRect(cv list("NW" "drawing") list(1.254:0.920 1.658:0.278))
    shape = dbCreateRect(cv list("RVTP" "drawing") list(1.254:0.920 1.658:0.278))
    shape = dbCreateRect(cv list("CT" "drawing") list(1.404:0.952 1.508:0.888))
    shape = dbCreateRect(cv list("PC" "drawing") list(1.342:0.920 1.362:0.378))
    shape = dbCreateRect(cv list("RX" "drawing") list(1.250:0.780 1.454:0.580))
    shape = dbCreateRect(cv list("PPLUS" "drawing") list(1.150:0.920 1.554:0.278))
    shape = dbCreateRect(cv list("NW" "drawing") list(1.150:0.920 1.554:0.278))
    shape = dbCreateRect(cv list("RVTP" "drawing") list(1.150:0.920 1.554:0.278))
    shape = dbCreateRect(cv list("CT" "drawing") list(1.300:0.492 1.404:0.428))
    shape = dbCreatePolygon(cv list("M1" "drawing") list(1.320:0.600 1.320:0.780 1.164:0.780 1.164:1.060 1.320:1.060 1.320:1.240 1.280:1.240 1.280:1.100 1.124:1.100 1.124:0.740 1.280:0.740 1.280:0.600))
    shape = dbCreatePolygon(cv list("M1" "drawing") list(1.404:0.740 1.476:0.740 1.476:1.100 1.404:1.100 1.404:1.060 1.436:1.060 1.436:0.780 1.404:0.780))
    shape = dbCreateRect(cv list("M1" "drawing") list(1.342:0.860 1.362:0.820))
    shape = dbCreateRect(cv list("M1" "drawing") list(1.342:1.020 1.362:0.980))
    shape = dbCreateRect(cv list("M1" "drawing") list(1.488:0.680 1.528:0.580))
    shape = dbCreateRect(cv list("M1" "drawing") list(1.488:1.260 1.528:1.160))
    shape = dbCreateRect(cv list("M1" "drawing") list(1.280:0.680 1.320:0.580))
    shape = dbCreateRect(cv list("M1" "drawing") list(1.280:1.260 1.320:1.160))
    shape = dbCreateRect(cv list("M1" "drawing") list(1.384:0.780 1.424:0.680))
    shape = dbCreateRect(cv list("M1" "drawing") list(1.384:1.160 1.424:1.060))
    shape = dbCreateRect(cv list("CB" "drawing") list(1.228:1.400 1.268:1.360))
    shape = dbCreateRect(cv list("CB" "drawing") list(1.228:0.480 1.268:0.440))
    shape = dbCreateRect(cv list("M1" "drawing") list(1.176:1.440 1.320:1.320))
    shape = dbCreateRect(cv list("M1" "drawing") list(1.176:0.520 1.320:0.400))
    shape = dbCreateRect(cv list("PC" "drawing") list(1.238:1.462 1.258:0.920))
    shape = dbCreateRect(cv list("RX" "drawing") list(1.146:1.260 1.350:1.060))
    shape = dbCreateRect(cv list("NPLUS" "drawing") list(1.046:1.562 1.450:0.920))
    shape = dbCreateRect(cv list("NW" "drawing") list(1.046:1.562 1.450:0.920))
    shape = dbCreateRect(cv list("LVTN" "drawing") list(1.046:1.562 1.450:0.920))
    shape = dbCreateRect(cv list("CT" "drawing") list(1.196:0.952 1.300:0.888))
    shape = dbCreateRect(cv list("PC" "drawing") list(1.238:0.920 1.258:0.378))
    shape = dbCreateRect(cv list("RX" "drawing") list(1.146:0.780 1.350:0.580))
    shape = dbCreateRect(cv list("PPLUS" "drawing") list(1.046:0.920 1.450:0.278))
    shape = dbCreateRect(cv list("NW" "drawing") list(1.046:0.920 1.450:0.278))
    shape = dbCreateRect(cv list("RVTP" "drawing") list(1.046:0.920 1.450:0.278))
    shape = dbCreateRect(cv list("CT" "drawing") list(1.196:0.952 1.300:0.888))
    shape = dbCreateRect(cv list("CA" "drawing") list(0.973:1.140 1.003:1.080))
    shape = dbCreateRect(cv list("CA" "drawing") list(0.973:0.760 1.003:0.700))
    shape = dbCreateRect(cv list("M1" "drawing") list(1.176:1.320 1.216:1.260))
    shape = dbCreateRect(cv list("CA" "drawing") list(1.181:1.240 1.211:1.180))
    shape = dbCreateRect(cv list("M1" "drawing") list(1.176:0.580 1.216:0.520))
    shape = dbCreateRect(cv list("CA" "drawing") list(1.181:0.660 1.211:0.600))
    shape = dbCreateRect(cv list("PC" "drawing") list(1.030:1.380 1.050:0.920))
    shape = dbCreateRect(cv list("RX" "drawing") list(0.938:1.260 1.142:1.060))
    shape = dbCreateRect(cv list("NPLUS" "drawing") list(0.838:1.480 1.242:0.920))
    shape = dbCreateRect(cv list("NW" "drawing") list(0.838:1.480 1.242:0.920))
    shape = dbCreateRect(cv list("LVTN" "drawing") list(0.838:1.480 1.242:0.920))
    shape = dbCreateRect(cv list("CT" "drawing") list(0.988:0.952 1.092:0.888))
    shape = dbCreateRect(cv list("PC" "drawing") list(1.030:0.920 1.050:0.460))
    shape = dbCreateRect(cv list("RX" "drawing") list(0.938:0.780 1.142:0.580))
    shape = dbCreateRect(cv list("PPLUS" "drawing") list(0.838:0.920 1.242:0.360))
    shape = dbCreateRect(cv list("NW" "drawing") list(0.838:0.920 1.242:0.360))
    shape = dbCreateRect(cv list("RVTP" "drawing") list(0.838:0.920 1.242:0.360))
    shape = dbCreateRect(cv list("CT" "drawing") list(0.988:0.952 1.092:0.888))
    shape = dbCreateRect(cv list("CB" "drawing") list(1.020:1.020 1.060:0.980))
    shape = dbCreateRect(cv list("CB" "drawing") list(1.020:0.860 1.060:0.820))
    shape = dbCreateRect(cv list("CB" "drawing") list(1.124:0.940 1.164:0.900))
    shape = dbCreateRect(cv list("M1" "drawing") list(0.968:1.440 1.216:1.320))
    shape = dbCreateRect(cv list("M1" "drawing") list(0.968:0.520 1.216:0.400))
    shape = dbCreateRect(cv list("PC" "drawing") list(1.030:1.462 1.050:0.920))
    shape = dbCreateRect(cv list("PC" "drawing") list(1.134:1.462 1.154:0.920))
    shape = dbCreateRect(cv list("RX" "drawing") list(0.938:1.260 1.246:1.060))
    shape = dbCreateRect(cv list("NPLUS" "drawing") list(0.838:1.562 1.346:0.920))
    shape = dbCreateRect(cv list("NW" "drawing") list(0.838:1.562 1.346:0.920))
    shape = dbCreateRect(cv list("LVTN" "drawing") list(0.838:1.562 1.346:0.920))
    shape = dbCreateRect(cv list("CT" "drawing") list(0.988:1.412 1.196:1.348))
    shape = dbCreateRect(cv list("PC" "drawing") list(1.030:0.920 1.050:0.378))
    shape = dbCreateRect(cv list("PC" "drawing") list(1.134:0.920 1.154:0.378))
    shape = dbCreateRect(cv list("RX" "drawing") list(0.938:0.780 1.246:0.580))
    shape = dbCreateRect(cv list("PPLUS" "drawing") list(0.838:0.920 1.346:0.278))
    shape = dbCreateRect(cv list("NW" "drawing") list(0.838:0.920 1.346:0.278))
    shape = dbCreateRect(cv list("RVTP" "drawing") list(0.838:0.920 1.346:0.278))
    shape = dbCreateRect(cv list("CT" "drawing") list(0.988:0.492 1.196:0.428))
    shape = dbCreatePolygon(cv list("M1" "drawing") list(0.988:0.780 0.852:0.780 0.852:1.060 0.988:1.060 0.988:1.100 0.812:1.100 0.812:0.740 0.988:0.740))
    shape = dbCreateRect(cv list("M1" "drawing") list(1.134:0.940 1.154:0.900))
    shape = dbCreateRect(cv list("M1" "drawing") list(1.030:0.860 1.050:0.820))
    shape = dbCreateRect(cv list("M1" "drawing") list(1.030:1.020 1.050:0.980))
    shape = dbCreateRect(cv list("M1" "drawing") list(1.176:0.680 1.216:0.580))
    shape = dbCreateRect(cv list("M1" "drawing") list(1.176:1.260 1.216:1.160))
    shape = dbCreateRect(cv list("M1" "drawing") list(0.968:0.780 1.008:0.680))
    shape = dbCreateRect(cv list("M1" "drawing") list(0.968:1.160 1.008:1.060))
    shape = dbCreateRect(cv list("CB" "drawing") list(0.916:1.400 0.956:1.360))
    shape = dbCreateRect(cv list("CB" "drawing") list(0.916:0.480 0.956:0.440))
    shape = dbCreateRect(cv list("M1" "drawing") list(0.864:1.440 1.008:1.320))
    shape = dbCreateRect(cv list("M1" "drawing") list(0.864:0.520 1.008:0.400))
    shape = dbCreateRect(cv list("PC" "drawing") list(0.926:1.462 0.946:0.920))
    shape = dbCreateRect(cv list("RX" "drawing") list(0.834:1.260 1.038:1.060))
    shape = dbCreateRect(cv list("NPLUS" "drawing") list(0.734:1.562 1.138:0.920))
    shape = dbCreateRect(cv list("NW" "drawing") list(0.734:1.562 1.138:0.920))
    shape = dbCreateRect(cv list("LVTN" "drawing") list(0.734:1.562 1.138:0.920))
    shape = dbCreateRect(cv list("CT" "drawing") list(0.884:0.952 0.988:0.888))
    shape = dbCreateRect(cv list("PC" "drawing") list(0.926:0.920 0.946:0.378))
    shape = dbCreateRect(cv list("RX" "drawing") list(0.834:0.780 1.038:0.580))
    shape = dbCreateRect(cv list("PPLUS" "drawing") list(0.734:0.920 1.138:0.278))
    shape = dbCreateRect(cv list("NW" "drawing") list(0.734:0.920 1.138:0.278))
    shape = dbCreateRect(cv list("RVTP" "drawing") list(0.734:0.920 1.138:0.278))
    shape = dbCreateRect(cv list("CT" "drawing") list(0.884:0.952 0.988:0.888))
    shape = dbCreateRect(cv list("CA" "drawing") list(0.869:1.240 0.899:1.180))
    shape = dbCreateRect(cv list("CA" "drawing") list(0.869:0.660 0.899:0.600))
    shape = dbCreateRect(cv list("M1" "drawing") list(0.760:1.320 0.800:1.260))
    shape = dbCreateRect(cv list("CA" "drawing") list(0.765:1.240 0.795:1.180))
    shape = dbCreateRect(cv list("M1" "drawing") list(0.760:0.580 0.800:0.520))
    shape = dbCreateRect(cv list("CA" "drawing") list(0.765:0.660 0.795:0.600))
    shape = dbCreateRect(cv list("CB" "drawing") list(0.812:0.940 0.852:0.900))
    shape = dbCreateRect(cv list("M1" "drawing") list(0.760:1.440 0.904:1.320))
    shape = dbCreateRect(cv list("M1" "drawing") list(0.760:0.520 0.904:0.400))
    shape = dbCreateRect(cv list("PC" "drawing") list(0.822:1.462 0.842:0.920))
    shape = dbCreateRect(cv list("RX" "drawing") list(0.730:1.260 0.934:1.060))
    shape = dbCreateRect(cv list("NPLUS" "drawing") list(0.630:1.562 1.034:0.920))
    shape = dbCreateRect(cv list("NW" "drawing") list(0.630:1.562 1.034:0.920))
    shape = dbCreateRect(cv list("LVTN" "drawing") list(0.630:1.562 1.034:0.920))
    shape = dbCreateRect(cv list("CT" "drawing") list(0.780:1.412 0.884:1.348))
    shape = dbCreateRect(cv list("PC" "drawing") list(0.822:0.920 0.842:0.378))
    shape = dbCreateRect(cv list("RX" "drawing") list(0.730:0.780 0.934:0.580))
    shape = dbCreateRect(cv list("PPLUS" "drawing") list(0.630:0.920 1.034:0.278))
    shape = dbCreateRect(cv list("NW" "drawing") list(0.630:0.920 1.034:0.278))
    shape = dbCreateRect(cv list("RVTP" "drawing") list(0.630:0.920 1.034:0.278))
    shape = dbCreateRect(cv list("CT" "drawing") list(0.780:0.492 0.884:0.428))
    shape = dbCreateRect(cv list("M1" "drawing") list(0.822:0.940 0.842:0.900))
    shape = dbCreateRect(cv list("M1" "drawing") list(0.760:0.680 0.800:0.580))
    shape = dbCreateRect(cv list("M1" "drawing") list(0.760:1.260 0.800:1.160))
    shape = dbCreateRect(cv list("M1" "drawing") list(0.864:0.680 0.904:0.580))
    shape = dbCreateRect(cv list("M1" "drawing") list(0.864:1.260 0.904:1.160))
    shape = dbCreateRect(cv list("CA" "drawing") list(0.661:1.140 0.691:1.080))
    shape = dbCreateRect(cv list("CA" "drawing") list(0.661:0.760 0.691:0.700))
    shape = dbCreateRect(cv list("CA" "drawing") list(0.557:1.240 0.587:1.180))
    shape = dbCreateRect(cv list("CA" "drawing") list(0.453:1.240 0.483:1.180))
    shape = dbCreateRect(cv list("M1" "drawing") list(0.448:0.580 0.488:0.520))
    shape = dbCreateRect(cv list("CA" "drawing") list(0.453:0.660 0.483:0.600))
    shape = dbCreateRect(cv list("M1" "drawing") list(0.344:1.320 0.384:1.260))
    shape = dbCreateRect(cv list("CA" "drawing") list(0.349:1.240 0.379:1.180))
    shape = dbCreateRect(cv list("M1" "drawing") list(0.760:1.320 0.800:1.260))
    shape = dbCreateRect(cv list("M1" "drawing") list(0.760:0.580 0.800:0.520))
    shape = dbCreateRect(cv list("CA" "drawing") list(0.765:1.240 0.795:1.180))
    shape = dbCreateRect(cv list("CA" "drawing") list(0.765:0.660 0.795:0.600))
    shape = dbCreateRect(cv list("CB" "drawing") list(0.708:1.400 0.748:1.360))
    shape = dbCreateRect(cv list("CB" "drawing") list(0.708:0.480 0.748:0.440))
    shape = dbCreateRect(cv list("CB" "drawing") list(0.604:1.020 0.644:0.980))
    shape = dbCreateRect(cv list("CB" "drawing") list(0.500:0.940 0.540:0.900))
    shape = dbCreateRect(cv list("CB" "drawing") list(0.396:0.860 0.436:0.820))
    shape = dbCreateRect(cv list("M1" "drawing") list(0.344:1.440 0.800:1.320))
    shape = dbCreateRect(cv list("M1" "drawing") list(0.344:0.520 0.800:0.400))
    shape = dbCreateRect(cv list("PC" "drawing") list(0.718:1.462 0.738:0.920))
    shape = dbCreateRect(cv list("RX" "drawing") list(0.626:1.260 0.830:1.060))
    shape = dbCreateRect(cv list("NPLUS" "drawing") list(0.526:1.562 0.930:0.920))
    shape = dbCreateRect(cv list("NW" "drawing") list(0.526:1.562 0.930:0.920))
    shape = dbCreateRect(cv list("LVTN" "drawing") list(0.526:1.562 0.930:0.920))
    shape = dbCreateRect(cv list("CT" "drawing") list(0.676:0.952 0.780:0.888))
    shape = dbCreateRect(cv list("PC" "drawing") list(0.614:1.462 0.634:0.920))
    shape = dbCreateRect(cv list("PC" "drawing") list(0.510:1.462 0.530:0.920))
    shape = dbCreateRect(cv list("PC" "drawing") list(0.406:1.462 0.426:0.920))
    shape = dbCreateRect(cv list("RX" "drawing") list(0.314:1.260 0.726:1.060))
    shape = dbCreateRect(cv list("NPLUS" "drawing") list(0.214:1.562 0.826:0.920))
    shape = dbCreateRect(cv list("NW" "drawing") list(0.214:1.562 0.826:0.920))
    shape = dbCreateRect(cv list("LVTN" "drawing") list(0.214:1.562 0.826:0.920))
    shape = dbCreateRect(cv list("CT" "drawing") list(0.364:1.412 0.676:1.348))
    shape = dbCreateRect(cv list("PC" "drawing") list(0.718:0.920 0.738:0.378))
    shape = dbCreateRect(cv list("RX" "drawing") list(0.626:0.780 0.830:0.580))
    shape = dbCreateRect(cv list("PPLUS" "drawing") list(0.526:0.920 0.930:0.278))
    shape = dbCreateRect(cv list("NW" "drawing") list(0.526:0.920 0.930:0.278))
    shape = dbCreateRect(cv list("RVTP" "drawing") list(0.526:0.920 0.930:0.278))
    shape = dbCreateRect(cv list("CT" "drawing") list(0.676:0.952 0.780:0.888))
    shape = dbCreateRect(cv list("PC" "drawing") list(0.614:0.920 0.634:0.378))
    shape = dbCreateRect(cv list("PC" "drawing") list(0.510:0.920 0.530:0.378))
    shape = dbCreateRect(cv list("PC" "drawing") list(0.406:0.920 0.426:0.378))
    shape = dbCreateRect(cv list("RX" "drawing") list(0.314:0.780 0.726:0.580))
    shape = dbCreateRect(cv list("PPLUS" "drawing") list(0.214:0.920 0.826:0.278))
    shape = dbCreateRect(cv list("NW" "drawing") list(0.214:0.920 0.826:0.278))
    shape = dbCreateRect(cv list("RVTP" "drawing") list(0.214:0.920 0.826:0.278))
    shape = dbCreateRect(cv list("CT" "drawing") list(0.364:0.492 0.676:0.428))
    shape = dbCreatePolygon(cv list("M1" "drawing") list(0.676:0.740 0.852:0.740 0.852:1.100 0.676:1.100 0.676:1.060 0.812:1.060 0.812:0.780 0.676:0.780))
    shape = dbCreateRect(cv list("M1" "drawing") list(0.468:1.190 0.572:1.230))
    shape = dbCreateRect(cv list("M1" "drawing") list(0.406:0.860 0.426:0.820))
    shape = dbCreateRect(cv list("M1" "drawing") list(0.510:0.940 0.530:0.900))
    shape = dbCreateRect(cv list("M1" "drawing") list(0.614:1.020 0.634:0.980))
    shape = dbCreateRect(cv list("M1" "drawing") list(0.760:0.680 0.800:0.580))
    shape = dbCreateRect(cv list("M1" "drawing") list(0.760:1.260 0.800:1.160))
    shape = dbCreateRect(cv list("M1" "drawing") list(0.344:1.260 0.384:1.160))
    shape = dbCreateRect(cv list("M1" "drawing") list(0.448:0.680 0.488:0.580))
    shape = dbCreateRect(cv list("M1" "drawing") list(0.448:1.260 0.488:1.160))
    shape = dbCreateRect(cv list("M1" "drawing") list(0.552:1.260 0.592:1.160))
    shape = dbCreateRect(cv list("M1" "drawing") list(0.656:0.780 0.696:0.680))
    shape = dbCreateRect(cv list("M1" "drawing") list(0.656:1.160 0.696:1.060))
    shape = dbCreateRect(cv list("CA" "drawing") list(0.245:1.140 0.275:1.080))
    shape = dbCreateRect(cv list("CA" "drawing") list(0.245:0.760 0.275:0.700))
    shape = dbCreateRect(cv list("M1" "drawing") list(0.136:1.320 0.176:1.260))
    shape = dbCreateRect(cv list("CA" "drawing") list(0.141:1.240 0.171:1.180))
    shape = dbCreateRect(cv list("M1" "drawing") list(0.136:0.580 0.176:0.520))
    shape = dbCreateRect(cv list("CA" "drawing") list(0.141:0.660 0.171:0.600))
    shape = dbCreateRect(cv list("M1" "drawing") list(0.344:1.320 0.384:1.260))
    shape = dbCreateRect(cv list("M1" "drawing") list(0.344:0.580 0.384:0.520))
    shape = dbCreateRect(cv list("CA" "drawing") list(0.349:1.240 0.379:1.180))
    shape = dbCreateRect(cv list("CA" "drawing") list(0.349:0.660 0.379:0.600))
    shape = dbCreateRect(cv list("CB" "drawing") list(0.292:1.400 0.332:1.360))
    shape = dbCreateRect(cv list("CB" "drawing") list(0.292:0.480 0.332:0.440))
    shape = dbCreateRect(cv list("CB" "drawing") list(0.188:0.940 0.228:0.900))
    shape = dbCreateRect(cv list("M1" "drawing") list(0.136:1.440 0.384:1.320))
    shape = dbCreateRect(cv list("M1" "drawing") list(0.136:0.520 0.384:0.400))
    shape = dbCreateRect(cv list("PC" "drawing") list(0.302:1.462 0.322:0.920))
    shape = dbCreateRect(cv list("RX" "drawing") list(0.210:1.260 0.414:1.060))
    shape = dbCreateRect(cv list("NPLUS" "drawing") list(0.110:1.562 0.514:0.920))
    shape = dbCreateRect(cv list("NW" "drawing") list(0.110:1.562 0.514:0.920))
    shape = dbCreateRect(cv list("LVTN" "drawing") list(0.110:1.562 0.514:0.920))
    shape = dbCreateRect(cv list("CT" "drawing") list(0.260:0.952 0.364:0.888))
    shape = dbCreateRect(cv list("PC" "drawing") list(0.198:1.462 0.218:0.920))
    shape = dbCreateRect(cv list("RX" "drawing") list(0.106:1.260 0.310:1.060))
    shape = dbCreateRect(cv list("NPLUS" "drawing") list(0.006:1.562 0.410:0.920))
    shape = dbCreateRect(cv list("NW" "drawing") list(0.006:1.562 0.410:0.920))
    shape = dbCreateRect(cv list("LVTN" "drawing") list(0.006:1.562 0.410:0.920))
    shape = dbCreateRect(cv list("CT" "drawing") list(0.156:1.412 0.260:1.348))
    shape = dbCreateRect(cv list("PC" "drawing") list(0.302:0.920 0.322:0.378))
    shape = dbCreateRect(cv list("RX" "drawing") list(0.210:0.780 0.414:0.580))
    shape = dbCreateRect(cv list("PPLUS" "drawing") list(0.110:0.920 0.514:0.278))
    shape = dbCreateRect(cv list("NW" "drawing") list(0.110:0.920 0.514:0.278))
    shape = dbCreateRect(cv list("RVTP" "drawing") list(0.110:0.920 0.514:0.278))
    shape = dbCreateRect(cv list("CT" "drawing") list(0.260:0.952 0.364:0.888))
    shape = dbCreateRect(cv list("PC" "drawing") list(0.198:0.920 0.218:0.378))
    shape = dbCreateRect(cv list("RX" "drawing") list(0.106:0.780 0.310:0.580))
    shape = dbCreateRect(cv list("PPLUS" "drawing") list(0.006:0.920 0.410:0.278))
    shape = dbCreateRect(cv list("NW" "drawing") list(0.006:0.920 0.410:0.278))
    shape = dbCreateRect(cv list("RVTP" "drawing") list(0.006:0.920 0.410:0.278))
    shape = dbCreateRect(cv list("CT" "drawing") list(0.156:0.492 0.260:0.428))
    shape = dbCreatePolygon(cv list("M1" "drawing") list(0.260:0.740 0.332:0.740 0.332:1.100 0.260:1.100 0.260:1.060 0.292:1.060 0.292:0.780 0.260:0.780))
    shape = dbCreateRect(cv list("M1" "drawing") list(0.198:0.940 0.218:0.900))
    shape = dbCreateRect(cv list("M1" "drawing") list(0.344:0.680 0.384:0.580))
    shape = dbCreateRect(cv list("M1" "drawing") list(0.344:1.260 0.384:1.160))
    shape = dbCreateRect(cv list("M1" "drawing") list(0.136:0.680 0.176:0.580))
    shape = dbCreateRect(cv list("M1" "drawing") list(0.136:1.260 0.176:1.160))
    shape = dbCreateRect(cv list("M1" "drawing") list(0.240:0.780 0.280:0.680))
    shape = dbCreateRect(cv list("M1" "drawing") list(0.240:1.160 0.280:1.060))
    shape = dbCreateRect(cv list("CA" "drawing") list(0.037:1.140 0.067:1.080))
    shape = dbCreateRect(cv list("CA" "drawing") list(0.037:0.760 0.067:0.700))
    shape = dbCreateRect(cv list("M1" "drawing") list(-0.072:1.320 -0.032:1.260))
    shape = dbCreateRect(cv list("CA" "drawing") list(-0.067:1.240 -0.037:1.180))
    shape = dbCreateRect(cv list("M1" "drawing") list(-0.072:0.580 -0.032:0.520))
    shape = dbCreateRect(cv list("CA" "drawing") list(-0.067:0.660 -0.037:0.600))
    shape = dbCreateRect(cv list("M1" "drawing") list(0.136:1.320 0.176:1.260))
    shape = dbCreateRect(cv list("M1" "drawing") list(0.136:0.580 0.176:0.520))
    shape = dbCreateRect(cv list("CA" "drawing") list(0.141:1.240 0.171:1.180))
    shape = dbCreateRect(cv list("CA" "drawing") list(0.141:0.660 0.171:0.600))
    shape = dbCreateRect(cv list("CB" "drawing") list(0.084:1.400 0.124:1.360))
    shape = dbCreateRect(cv list("CB" "drawing") list(0.084:0.480 0.124:0.440))
    shape = dbCreateRect(cv list("CB" "drawing") list(-0.020:1.020 0.020:0.980))
    shape = dbCreateRect(cv list("M1" "drawing") list(-0.072:1.440 0.176:1.320))
    shape = dbCreateRect(cv list("M1" "drawing") list(-0.072:0.520 0.176:0.400))
    shape = dbCreateRect(cv list("PC" "drawing") list(0.094:1.462 0.114:0.920))
    shape = dbCreateRect(cv list("RX" "drawing") list(0.002:1.260 0.206:1.060))
    shape = dbCreateRect(cv list("NPLUS" "drawing") list(-0.098:1.562 0.306:0.920))
    shape = dbCreateRect(cv list("NW" "drawing") list(-0.098:1.562 0.306:0.920))
    shape = dbCreateRect(cv list("LVTN" "drawing") list(-0.098:1.562 0.306:0.920))
    shape = dbCreateRect(cv list("CT" "drawing") list(0.052:0.952 0.156:0.888))
    shape = dbCreateRect(cv list("PC" "drawing") list(-0.010:1.462 0.010:0.920))
    shape = dbCreateRect(cv list("RX" "drawing") list(-0.102:1.260 0.102:1.060))
    shape = dbCreateRect(cv list("NPLUS" "drawing") list(-0.202:1.562 0.202:0.920))
    shape = dbCreateRect(cv list("NW" "drawing") list(-0.202:1.562 0.202:0.920))
    shape = dbCreateRect(cv list("LVTN" "drawing") list(-0.202:1.562 0.202:0.920))
    shape = dbCreateRect(cv list("CT" "drawing") list(-0.052:1.412 0.052:1.348))
    shape = dbCreateRect(cv list("PC" "drawing") list(0.094:0.920 0.114:0.378))
    shape = dbCreateRect(cv list("RX" "drawing") list(0.002:0.780 0.206:0.580))
    shape = dbCreateRect(cv list("PPLUS" "drawing") list(-0.098:0.920 0.306:0.278))
    shape = dbCreateRect(cv list("NW" "drawing") list(-0.098:0.920 0.306:0.278))
    shape = dbCreateRect(cv list("RVTP" "drawing") list(-0.098:0.920 0.306:0.278))
    shape = dbCreateRect(cv list("CT" "drawing") list(0.052:0.952 0.156:0.888))
    shape = dbCreateRect(cv list("PC" "drawing") list(-0.010:0.920 0.010:0.378))
    shape = dbCreateRect(cv list("RX" "drawing") list(-0.102:0.780 0.102:0.580))
    shape = dbCreateRect(cv list("PPLUS" "drawing") list(-0.202:0.920 0.202:0.278))
    shape = dbCreateRect(cv list("NW" "drawing") list(-0.202:0.920 0.202:0.278))
    shape = dbCreateRect(cv list("RVTP" "drawing") list(-0.202:0.920 0.202:0.278))
    shape = dbCreateRect(cv list("CT" "drawing") list(-0.052:0.492 0.052:0.428))
    shape = dbCreatePolygon(cv list("M1" "drawing") list(0.052:0.740 0.124:0.740 0.124:1.100 0.052:1.100 0.052:1.060 0.084:1.060 0.084:0.780 0.052:0.780))
    shape = dbCreateRect(cv list("M1" "drawing") list(-0.010:1.020 0.010:0.980))
    shape = dbCreateRect(cv list("M1" "drawing") list(0.136:0.680 0.176:0.580))
    shape = dbCreateRect(cv list("M1" "drawing") list(0.136:1.260 0.176:1.160))
    shape = dbCreateRect(cv list("M1" "drawing") list(-0.072:0.680 -0.032:0.580))
    shape = dbCreateRect(cv list("M1" "drawing") list(-0.072:1.260 -0.032:1.160))
    shape = dbCreateRect(cv list("M1" "drawing") list(0.032:0.780 0.072:0.680))
    shape = dbCreateRect(cv list("M1" "drawing") list(0.032:1.160 0.072:1.060))
    shape = dbCreateRect(cv list("M2" "drawing") list(-0.228:1.020 -0.188:0.980))
    shape = dbCreateRect(cv list("M1" "drawing") list(-0.228:1.020 -0.188:0.980))
    shape = dbCreateRect(cv list("M2" "drawing") list(-0.852:0.940 -0.812:0.900))
    shape = dbCreateRect(cv list("M1" "drawing") list(-0.852:0.940 -0.812:0.900))
    shape = dbCreateRect(cv list("V1" "drawing") list(-0.872:0.940 -0.792:0.900))
    shape = dbCreateRect(cv list("V1" "drawing") list(-0.248:1.020 -0.168:0.980))
    shape = dbCreatePolygon(cv list("M2" "drawing") list(-0.812:0.920 -0.812:1.060 -0.228:1.060 -0.228:1.000 -0.188:1.000 -0.188:1.100 -0.852:1.100 -0.852:0.920))
    shape = dbCreatePolygon(cv list("M1" "drawing") list(-0.332:0.920 -0.332:0.820 -0.104:0.820 -0.104:0.860 -0.292:0.860 -0.292:0.920))
    shape = dbCreatePolygon(cv list("M1" "drawing") list(-1.372:0.920 -1.372:0.820 -1.144:0.820 -1.144:0.860 -1.332:0.860 -1.332:0.920))
    shape = dbCreateRect(cv list("M1" "drawing") list(-0.072:1.320 -0.032:1.260))
    shape = dbCreateRect(cv list("CA" "drawing") list(-0.067:1.240 -0.037:1.180))
    shape = dbCreateRect(cv list("M1" "drawing") list(-0.072:0.580 -0.032:0.520))
    shape = dbCreateRect(cv list("CA" "drawing") list(-0.067:0.660 -0.037:0.600))
    shape = dbCreateRect(cv list("CA" "drawing") list(-0.171:0.760 -0.141:0.700))
    shape = dbCreateRect(cv list("CA" "drawing") list(-0.275:1.140 -0.245:1.080))
    shape = dbCreateRect(cv list("M1" "drawing") list(-0.280:0.580 -0.240:0.520))
    shape = dbCreateRect(cv list("CA" "drawing") list(-0.275:0.660 -0.245:0.600))
    shape = dbCreateRect(cv list("CB" "drawing") list(-0.124:0.860 -0.084:0.820))
    shape = dbCreateRect(cv list("CB" "drawing") list(-0.228:1.020 -0.188:0.980))
    shape = dbCreateRect(cv list("M1" "drawing") list(-0.280:1.440 -0.032:1.320))
    shape = dbCreateRect(cv list("M1" "drawing") list(-0.280:0.520 -0.032:0.400))
    shape = dbCreateRect(cv list("PC" "drawing") list(-0.114:1.462 -0.094:0.920))
    shape = dbCreateRect(cv list("PC" "drawing") list(-0.218:1.462 -0.198:0.920))
    shape = dbCreateRect(cv list("RX" "drawing") list(-0.310:1.260 -0.002:1.060))
    shape = dbCreateRect(cv list("NPLUS" "drawing") list(-0.410:1.562 0.098:0.920))
    shape = dbCreateRect(cv list("NW" "drawing") list(-0.410:1.562 0.098:0.920))
    shape = dbCreateRect(cv list("LVTN" "drawing") list(-0.410:1.562 0.098:0.920))
    shape = dbCreateRect(cv list("CT" "drawing") list(-0.260:1.412 -0.052:1.348))
    shape = dbCreateRect(cv list("PC" "drawing") list(-0.114:0.920 -0.094:0.378))
    shape = dbCreateRect(cv list("PC" "drawing") list(-0.218:0.920 -0.198:0.378))
    shape = dbCreateRect(cv list("RX" "drawing") list(-0.310:0.780 -0.002:0.580))
    shape = dbCreateRect(cv list("PPLUS" "drawing") list(-0.410:0.920 0.098:0.278))
    shape = dbCreateRect(cv list("NW" "drawing") list(-0.410:0.920 0.098:0.278))
    shape = dbCreateRect(cv list("RVTP" "drawing") list(-0.410:0.920 0.098:0.278))
    shape = dbCreateRect(cv list("CT" "drawing") list(-0.260:0.492 -0.052:0.428))
    shape = dbCreateRect(cv list("M1" "drawing") list(-0.252:0.820 -0.060:0.860))
    shape = dbCreateRect(cv list("M1" "drawing") list(-0.252:0.980 -0.060:1.020))
    shape = dbCreatePolygon(cv list("M1" "drawing") list(-0.260:1.060 -0.020:1.060 -0.020:0.780 -0.156:0.780 -0.156:0.740 0.020:0.740 0.020:1.100 -0.260:1.100))
    shape = dbCreateRect(cv list("M1" "drawing") list(-0.218:1.020 -0.198:0.980))
    shape = dbCreateRect(cv list("M1" "drawing") list(-0.114:0.860 -0.094:0.820))
    shape = dbCreateRect(cv list("M1" "drawing") list(-0.280:0.680 -0.240:0.580))
    shape = dbCreateRect(cv list("M1" "drawing") list(-0.280:1.160 -0.240:1.060))
    shape = dbCreateRect(cv list("M1" "drawing") list(-0.176:0.780 -0.136:0.680))
    shape = dbCreateRect(cv list("M1" "drawing") list(-0.072:0.680 -0.032:0.580))
    shape = dbCreateRect(cv list("M1" "drawing") list(-0.072:1.260 -0.032:1.160))
    shape = dbCreateRect(cv list("CB" "drawing") list(-0.332:1.400 -0.292:1.360))
    shape = dbCreateRect(cv list("CB" "drawing") list(-0.332:0.480 -0.292:0.440))
    shape = dbCreateRect(cv list("M1" "drawing") list(-0.384:1.440 -0.240:1.320))
    shape = dbCreateRect(cv list("M1" "drawing") list(-0.384:0.520 -0.240:0.400))
    shape = dbCreateRect(cv list("PC" "drawing") list(-0.322:1.462 -0.302:0.920))
    shape = dbCreateRect(cv list("RX" "drawing") list(-0.414:1.260 -0.210:1.060))
    shape = dbCreateRect(cv list("NPLUS" "drawing") list(-0.514:1.562 -0.110:0.920))
    shape = dbCreateRect(cv list("NW" "drawing") list(-0.514:1.562 -0.110:0.920))
    shape = dbCreateRect(cv list("LVTN" "drawing") list(-0.514:1.562 -0.110:0.920))
    shape = dbCreateRect(cv list("CT" "drawing") list(-0.364:0.952 -0.260:0.888))
    shape = dbCreateRect(cv list("PC" "drawing") list(-0.322:0.920 -0.302:0.378))
    shape = dbCreateRect(cv list("RX" "drawing") list(-0.414:0.780 -0.210:0.580))
    shape = dbCreateRect(cv list("PPLUS" "drawing") list(-0.514:0.920 -0.110:0.278))
    shape = dbCreateRect(cv list("NW" "drawing") list(-0.514:0.920 -0.110:0.278))
    shape = dbCreateRect(cv list("RVTP" "drawing") list(-0.514:0.920 -0.110:0.278))
    shape = dbCreateRect(cv list("CT" "drawing") list(-0.364:0.952 -0.260:0.888))
    shape = dbCreateRect(cv list("M1" "drawing") list(-0.592:1.260 -0.552:1.160))
    shape = dbCreateRect(cv list("M1" "drawing") list(-0.592:0.680 -0.552:0.580))
    shape = dbCreateRect(cv list("M1" "drawing") list(-0.696:1.160 -0.656:1.060))
    shape = dbCreateRect(cv list("M1" "drawing") list(-0.800:1.260 -0.760:1.160))
    shape = dbCreateRect(cv list("M1" "drawing") list(-0.800:0.780 -0.760:0.680))
    shape = dbCreateRect(cv list("M1" "drawing") list(-0.634:0.860 -0.614:0.820))
    shape = dbCreateRect(cv list("M1" "drawing") list(-0.738:1.020 -0.718:0.980))
    shape = dbCreatePolygon(cv list("M1" "drawing") list(-0.780:0.740 -0.500:0.740 -0.500:1.100 -0.676:1.100 -0.676:1.060 -0.540:1.060 -0.540:0.780 -0.780:0.780))
    shape = dbCreateRect(cv list("M1" "drawing") list(-0.772:0.980 -0.580:1.020))
    shape = dbCreateRect(cv list("M1" "drawing") list(-0.772:0.820 -0.580:0.860))
    shape = dbCreateRect(cv list("CT" "drawing") list(-0.780:0.492 -0.572:0.428))
    shape = dbCreateRect(cv list("RVTP" "drawing") list(-0.930:0.920 -0.422:0.278))
    shape = dbCreateRect(cv list("NW" "drawing") list(-0.930:0.920 -0.422:0.278))
    shape = dbCreateRect(cv list("PPLUS" "drawing") list(-0.930:0.920 -0.422:0.278))
    shape = dbCreateRect(cv list("RX" "drawing") list(-0.830:0.780 -0.522:0.580))
    shape = dbCreateRect(cv list("PC" "drawing") list(-0.738:0.920 -0.718:0.378))
    shape = dbCreateRect(cv list("PC" "drawing") list(-0.634:0.920 -0.614:0.378))
    shape = dbCreateRect(cv list("CT" "drawing") list(-0.780:1.412 -0.572:1.348))
    shape = dbCreateRect(cv list("LVTN" "drawing") list(-0.930:1.562 -0.422:0.920))
    shape = dbCreateRect(cv list("NW" "drawing") list(-0.930:1.562 -0.422:0.920))
    shape = dbCreateRect(cv list("NPLUS" "drawing") list(-0.930:1.562 -0.422:0.920))
    shape = dbCreateRect(cv list("RX" "drawing") list(-0.830:1.260 -0.522:1.060))
    shape = dbCreateRect(cv list("PC" "drawing") list(-0.738:1.462 -0.718:0.920))
    shape = dbCreateRect(cv list("PC" "drawing") list(-0.634:1.462 -0.614:0.920))
    shape = dbCreateRect(cv list("M1" "drawing") list(-0.800:0.520 -0.552:0.400))
    shape = dbCreateRect(cv list("M1" "drawing") list(-0.800:1.440 -0.552:1.320))
    shape = dbCreateRect(cv list("CB" "drawing") list(-0.748:1.020 -0.708:0.980))
    shape = dbCreateRect(cv list("CB" "drawing") list(-0.644:0.860 -0.604:0.820))
    shape = dbCreateRect(cv list("CA" "drawing") list(-0.795:0.760 -0.765:0.700))
    shape = dbCreateRect(cv list("CA" "drawing") list(-0.795:1.240 -0.765:1.180))
    shape = dbCreateRect(cv list("M1" "drawing") list(-0.800:1.320 -0.760:1.260))
    shape = dbCreateRect(cv list("CA" "drawing") list(-0.691:1.140 -0.661:1.080))
    shape = dbCreateRect(cv list("CA" "drawing") list(-0.587:0.660 -0.557:0.600))
    shape = dbCreateRect(cv list("M1" "drawing") list(-0.592:0.580 -0.552:0.520))
    shape = dbCreateRect(cv list("CA" "drawing") list(-0.587:1.240 -0.557:1.180))
    shape = dbCreateRect(cv list("M1" "drawing") list(-0.592:1.320 -0.552:1.260))
    shape = dbCreateRect(cv list("CT" "drawing") list(-0.572:0.952 -0.468:0.888))
    shape = dbCreateRect(cv list("RVTP" "drawing") list(-0.722:0.920 -0.318:0.278))
    shape = dbCreateRect(cv list("NW" "drawing") list(-0.722:0.920 -0.318:0.278))
    shape = dbCreateRect(cv list("PPLUS" "drawing") list(-0.722:0.920 -0.318:0.278))
    shape = dbCreateRect(cv list("RX" "drawing") list(-0.622:0.780 -0.418:0.580))
    shape = dbCreateRect(cv list("PC" "drawing") list(-0.530:0.920 -0.510:0.378))
    shape = dbCreateRect(cv list("CT" "drawing") list(-0.572:0.952 -0.468:0.888))
    shape = dbCreateRect(cv list("LVTN" "drawing") list(-0.722:1.562 -0.318:0.920))
    shape = dbCreateRect(cv list("NW" "drawing") list(-0.722:1.562 -0.318:0.920))
    shape = dbCreateRect(cv list("NPLUS" "drawing") list(-0.722:1.562 -0.318:0.920))
    shape = dbCreateRect(cv list("RX" "drawing") list(-0.622:1.260 -0.418:1.060))
    shape = dbCreateRect(cv list("PC" "drawing") list(-0.530:1.462 -0.510:0.920))
    shape = dbCreateRect(cv list("M1" "drawing") list(-0.592:0.520 -0.448:0.400))
    shape = dbCreateRect(cv list("M1" "drawing") list(-0.592:1.440 -0.448:1.320))
    shape = dbCreateRect(cv list("CB" "drawing") list(-0.540:0.480 -0.500:0.440))
    shape = dbCreateRect(cv list("CB" "drawing") list(-0.540:1.400 -0.500:1.360))
    shape = dbCreateRect(cv list("M1" "drawing") list(-0.384:1.160 -0.344:1.060))
    shape = dbCreateRect(cv list("M1" "drawing") list(-0.384:0.780 -0.344:0.680))
    shape = dbCreateRect(cv list("M1" "drawing") list(-0.488:1.260 -0.448:1.160))
    shape = dbCreateRect(cv list("M1" "drawing") list(-0.488:0.680 -0.448:0.580))
    shape = dbCreateRect(cv list("M1" "drawing") list(-0.426:0.940 -0.406:0.900))
    shape = dbCreatePolygon(cv list("M1" "drawing") list(-0.364:0.740 -0.292:0.740 -0.292:1.100 -0.364:1.100 -0.364:1.060 -0.332:1.060 -0.332:0.780 -0.364:0.780))
    shape = dbCreateRect(cv list("CT" "drawing") list(-0.468:0.492 -0.364:0.428))
    shape = dbCreateRect(cv list("RVTP" "drawing") list(-0.618:0.920 -0.214:0.278))
    shape = dbCreateRect(cv list("NW" "drawing") list(-0.618:0.920 -0.214:0.278))
    shape = dbCreateRect(cv list("PPLUS" "drawing") list(-0.618:0.920 -0.214:0.278))
    shape = dbCreateRect(cv list("RX" "drawing") list(-0.518:0.780 -0.314:0.580))
    shape = dbCreateRect(cv list("PC" "drawing") list(-0.426:0.920 -0.406:0.378))
    shape = dbCreateRect(cv list("CT" "drawing") list(-0.468:1.412 -0.364:1.348))
    shape = dbCreateRect(cv list("LVTN" "drawing") list(-0.618:1.562 -0.214:0.920))
    shape = dbCreateRect(cv list("NW" "drawing") list(-0.618:1.562 -0.214:0.920))
    shape = dbCreateRect(cv list("NPLUS" "drawing") list(-0.618:1.562 -0.214:0.920))
    shape = dbCreateRect(cv list("RX" "drawing") list(-0.518:1.260 -0.314:1.060))
    shape = dbCreateRect(cv list("PC" "drawing") list(-0.426:1.462 -0.406:0.920))
    shape = dbCreateRect(cv list("M1" "drawing") list(-0.488:0.520 -0.344:0.400))
    shape = dbCreateRect(cv list("M1" "drawing") list(-0.488:1.440 -0.344:1.320))
    shape = dbCreateRect(cv list("CB" "drawing") list(-0.436:0.940 -0.396:0.900))
    shape = dbCreateRect(cv list("CA" "drawing") list(-0.483:0.660 -0.453:0.600))
    shape = dbCreateRect(cv list("M1" "drawing") list(-0.488:0.580 -0.448:0.520))
    shape = dbCreateRect(cv list("CA" "drawing") list(-0.483:1.240 -0.453:1.180))
    shape = dbCreateRect(cv list("M1" "drawing") list(-0.488:1.320 -0.448:1.260))
    shape = dbCreateRect(cv list("CA" "drawing") list(-0.379:0.760 -0.349:0.700))
    shape = dbCreateRect(cv list("CA" "drawing") list(-0.379:1.140 -0.349:1.080))
    shape = dbCreateRect(cv list("M1" "drawing") list(-0.520:0.900 -0.372:0.940))
    shape = dbCreateRect(cv list("CB" "drawing") list(-0.852:1.400 -0.812:1.360))
    shape = dbCreateRect(cv list("CB" "drawing") list(-0.852:0.480 -0.812:0.440))
    shape = dbCreateRect(cv list("M1" "drawing") list(-0.904:1.440 -0.760:1.320))
    shape = dbCreateRect(cv list("M1" "drawing") list(-0.904:0.520 -0.760:0.400))
    shape = dbCreateRect(cv list("PC" "drawing") list(-0.842:1.462 -0.822:0.920))
    shape = dbCreateRect(cv list("RX" "drawing") list(-0.934:1.260 -0.730:1.060))
    shape = dbCreateRect(cv list("NPLUS" "drawing") list(-1.034:1.562 -0.630:0.920))
    shape = dbCreateRect(cv list("NW" "drawing") list(-1.034:1.562 -0.630:0.920))
    shape = dbCreateRect(cv list("LVTN" "drawing") list(-1.034:1.562 -0.630:0.920))
    shape = dbCreateRect(cv list("CT" "drawing") list(-0.884:0.952 -0.780:0.888))
    shape = dbCreateRect(cv list("PC" "drawing") list(-0.842:0.920 -0.822:0.378))
    shape = dbCreateRect(cv list("RX" "drawing") list(-0.934:0.780 -0.730:0.580))
    shape = dbCreateRect(cv list("PPLUS" "drawing") list(-1.034:0.920 -0.630:0.278))
    shape = dbCreateRect(cv list("NW" "drawing") list(-1.034:0.920 -0.630:0.278))
    shape = dbCreateRect(cv list("RVTP" "drawing") list(-1.034:0.920 -0.630:0.278))
    shape = dbCreateRect(cv list("CT" "drawing") list(-0.884:0.952 -0.780:0.888))
    shape = dbCreateRect(cv list("M1" "drawing") list(-1.112:1.260 -1.072:1.160))
    shape = dbCreateRect(cv list("M1" "drawing") list(-1.112:0.680 -1.072:0.580))
    shape = dbCreateRect(cv list("M1" "drawing") list(-1.216:0.780 -1.176:0.680))
    shape = dbCreateRect(cv list("M1" "drawing") list(-1.320:1.160 -1.280:1.060))
    shape = dbCreateRect(cv list("M1" "drawing") list(-1.320:0.680 -1.280:0.580))
    shape = dbCreateRect(cv list("M1" "drawing") list(-1.154:0.860 -1.134:0.820))
    shape = dbCreateRect(cv list("M1" "drawing") list(-1.258:1.020 -1.238:0.980))
    shape = dbCreatePolygon(cv list("M1" "drawing") list(-1.300:1.060 -1.060:1.060 -1.060:0.780 -1.196:0.780 -1.196:0.740 -1.020:0.740 -1.020:1.100 -1.300:1.100))
    shape = dbCreateRect(cv list("M1" "drawing") list(-1.292:0.980 -1.100:1.020))
    shape = dbCreateRect(cv list("M1" "drawing") list(-1.292:0.820 -1.100:0.860))
    shape = dbCreateRect(cv list("CT" "drawing") list(-1.300:0.492 -1.092:0.428))
    shape = dbCreateRect(cv list("RVTP" "drawing") list(-1.450:0.920 -0.942:0.278))
    shape = dbCreateRect(cv list("NW" "drawing") list(-1.450:0.920 -0.942:0.278))
    shape = dbCreateRect(cv list("PPLUS" "drawing") list(-1.450:0.920 -0.942:0.278))
    shape = dbCreateRect(cv list("RX" "drawing") list(-1.350:0.780 -1.042:0.580))
    shape = dbCreateRect(cv list("PC" "drawing") list(-1.258:0.920 -1.238:0.378))
    shape = dbCreateRect(cv list("PC" "drawing") list(-1.154:0.920 -1.134:0.378))
    shape = dbCreateRect(cv list("CT" "drawing") list(-1.300:1.412 -1.092:1.348))
    shape = dbCreateRect(cv list("LVTN" "drawing") list(-1.450:1.562 -0.942:0.920))
    shape = dbCreateRect(cv list("NW" "drawing") list(-1.450:1.562 -0.942:0.920))
    shape = dbCreateRect(cv list("NPLUS" "drawing") list(-1.450:1.562 -0.942:0.920))
    shape = dbCreateRect(cv list("RX" "drawing") list(-1.350:1.260 -1.042:1.060))
    shape = dbCreateRect(cv list("PC" "drawing") list(-1.258:1.462 -1.238:0.920))
    shape = dbCreateRect(cv list("PC" "drawing") list(-1.154:1.462 -1.134:0.920))
    shape = dbCreateRect(cv list("M1" "drawing") list(-1.320:0.520 -1.072:0.400))
    shape = dbCreateRect(cv list("M1" "drawing") list(-1.320:1.440 -1.072:1.320))
    shape = dbCreateRect(cv list("CB" "drawing") list(-1.268:1.020 -1.228:0.980))
    shape = dbCreateRect(cv list("CB" "drawing") list(-1.164:0.860 -1.124:0.820))
    shape = dbCreateRect(cv list("CA" "drawing") list(-1.315:0.660 -1.285:0.600))
    shape = dbCreateRect(cv list("M1" "drawing") list(-1.320:0.580 -1.280:0.520))
    shape = dbCreateRect(cv list("CA" "drawing") list(-1.315:1.140 -1.285:1.080))
    shape = dbCreateRect(cv list("CA" "drawing") list(-1.211:0.760 -1.181:0.700))
    shape = dbCreateRect(cv list("CA" "drawing") list(-1.107:0.660 -1.077:0.600))
    shape = dbCreateRect(cv list("M1" "drawing") list(-1.112:0.580 -1.072:0.520))
    shape = dbCreateRect(cv list("CA" "drawing") list(-1.107:1.240 -1.077:1.180))
    shape = dbCreateRect(cv list("M1" "drawing") list(-1.112:1.320 -1.072:1.260))
    shape = dbCreateRect(cv list("CT" "drawing") list(-1.092:0.952 -0.988:0.888))
    shape = dbCreateRect(cv list("RVTP" "drawing") list(-1.242:0.920 -0.838:0.278))
    shape = dbCreateRect(cv list("NW" "drawing") list(-1.242:0.920 -0.838:0.278))
    shape = dbCreateRect(cv list("PPLUS" "drawing") list(-1.242:0.920 -0.838:0.278))
    shape = dbCreateRect(cv list("RX" "drawing") list(-1.142:0.780 -0.938:0.580))
    shape = dbCreateRect(cv list("PC" "drawing") list(-1.050:0.920 -1.030:0.378))
    shape = dbCreateRect(cv list("CT" "drawing") list(-1.092:0.952 -0.988:0.888))
    shape = dbCreateRect(cv list("LVTN" "drawing") list(-1.242:1.562 -0.838:0.920))
    shape = dbCreateRect(cv list("NW" "drawing") list(-1.242:1.562 -0.838:0.920))
    shape = dbCreateRect(cv list("NPLUS" "drawing") list(-1.242:1.562 -0.838:0.920))
    shape = dbCreateRect(cv list("RX" "drawing") list(-1.142:1.260 -0.938:1.060))
    shape = dbCreateRect(cv list("PC" "drawing") list(-1.050:1.462 -1.030:0.920))
    shape = dbCreateRect(cv list("M1" "drawing") list(-1.112:0.520 -0.968:0.400))
    shape = dbCreateRect(cv list("M1" "drawing") list(-1.112:1.440 -0.968:1.320))
    shape = dbCreateRect(cv list("CB" "drawing") list(-1.060:0.480 -1.020:0.440))
    shape = dbCreateRect(cv list("CB" "drawing") list(-1.060:1.400 -1.020:1.360))
    shape = dbCreateRect(cv list("M1" "drawing") list(-0.904:1.160 -0.864:1.060))
    shape = dbCreateRect(cv list("M1" "drawing") list(-0.904:0.780 -0.864:0.680))
    shape = dbCreateRect(cv list("M1" "drawing") list(-1.008:1.260 -0.968:1.160))
    shape = dbCreateRect(cv list("M1" "drawing") list(-1.008:0.680 -0.968:0.580))
    shape = dbCreateRect(cv list("M1" "drawing") list(-0.946:0.940 -0.926:0.900))
    shape = dbCreatePolygon(cv list("M1" "drawing") list(-0.884:0.740 -0.812:0.740 -0.812:1.100 -0.884:1.100 -0.884:1.060 -0.852:1.060 -0.852:0.780 -0.884:0.780))
    shape = dbCreateRect(cv list("CT" "drawing") list(-0.988:0.492 -0.884:0.428))
    shape = dbCreateRect(cv list("RVTP" "drawing") list(-1.138:0.920 -0.734:0.278))
    shape = dbCreateRect(cv list("NW" "drawing") list(-1.138:0.920 -0.734:0.278))
    shape = dbCreateRect(cv list("PPLUS" "drawing") list(-1.138:0.920 -0.734:0.278))
    shape = dbCreateRect(cv list("RX" "drawing") list(-1.038:0.780 -0.834:0.580))
    shape = dbCreateRect(cv list("PC" "drawing") list(-0.946:0.920 -0.926:0.378))
    shape = dbCreateRect(cv list("CT" "drawing") list(-0.988:1.412 -0.884:1.348))
    shape = dbCreateRect(cv list("LVTN" "drawing") list(-1.138:1.562 -0.734:0.920))
    shape = dbCreateRect(cv list("NW" "drawing") list(-1.138:1.562 -0.734:0.920))
    shape = dbCreateRect(cv list("NPLUS" "drawing") list(-1.138:1.562 -0.734:0.920))
    shape = dbCreateRect(cv list("RX" "drawing") list(-1.038:1.260 -0.834:1.060))
    shape = dbCreateRect(cv list("PC" "drawing") list(-0.946:1.462 -0.926:0.920))
    shape = dbCreateRect(cv list("M1" "drawing") list(-1.008:0.520 -0.864:0.400))
    shape = dbCreateRect(cv list("M1" "drawing") list(-1.008:1.440 -0.864:1.320))
    shape = dbCreateRect(cv list("CB" "drawing") list(-0.956:0.940 -0.916:0.900))
    shape = dbCreateRect(cv list("CA" "drawing") list(-1.003:0.660 -0.973:0.600))
    shape = dbCreateRect(cv list("M1" "drawing") list(-1.008:0.580 -0.968:0.520))
    shape = dbCreateRect(cv list("CA" "drawing") list(-1.003:1.240 -0.973:1.180))
    shape = dbCreateRect(cv list("M1" "drawing") list(-1.008:1.320 -0.968:1.260))
    shape = dbCreateRect(cv list("CA" "drawing") list(-0.899:0.760 -0.869:0.700))
    shape = dbCreateRect(cv list("CA" "drawing") list(-0.899:1.140 -0.869:1.080))
    shape = dbCreateRect(cv list("M1" "drawing") list(-1.040:0.900 -0.892:0.940))
    shape = dbCreateRect(cv list("CB" "drawing") list(-1.372:1.400 -1.332:1.360))
    shape = dbCreateRect(cv list("CB" "drawing") list(-1.372:0.480 -1.332:0.440))
    shape = dbCreateRect(cv list("M1" "drawing") list(-1.424:1.440 -1.280:1.320))
    shape = dbCreateRect(cv list("M1" "drawing") list(-1.424:0.520 -1.280:0.400))
    shape = dbCreateRect(cv list("PC" "drawing") list(-1.362:1.462 -1.342:0.920))
    shape = dbCreateRect(cv list("RX" "drawing") list(-1.454:1.260 -1.250:1.060))
    shape = dbCreateRect(cv list("NPLUS" "drawing") list(-1.554:1.562 -1.150:0.920))
    shape = dbCreateRect(cv list("NW" "drawing") list(-1.554:1.562 -1.150:0.920))
    shape = dbCreateRect(cv list("LVTN" "drawing") list(-1.554:1.562 -1.150:0.920))
    shape = dbCreateRect(cv list("CT" "drawing") list(-1.404:0.952 -1.300:0.888))
    shape = dbCreateRect(cv list("PC" "drawing") list(-1.362:0.920 -1.342:0.378))
    shape = dbCreateRect(cv list("RX" "drawing") list(-1.454:0.780 -1.250:0.580))
    shape = dbCreateRect(cv list("PPLUS" "drawing") list(-1.554:0.920 -1.150:0.278))
    shape = dbCreateRect(cv list("NW" "drawing") list(-1.554:0.920 -1.150:0.278))
    shape = dbCreateRect(cv list("RVTP" "drawing") list(-1.554:0.920 -1.150:0.278))
    shape = dbCreateRect(cv list("CT" "drawing") list(-1.404:0.952 -1.300:0.888))
    shape = dbCreateRect(cv list("M1" "drawing") list(-1.632:1.260 -1.592:1.160))
    shape = dbCreateRect(cv list("M1" "drawing") list(-1.632:0.680 -1.592:0.580))
    shape = dbCreateRect(cv list("M1" "drawing") list(-1.736:1.160 -1.696:1.060))
    shape = dbCreateRect(cv list("M1" "drawing") list(-1.840:1.260 -1.800:1.160))
    shape = dbCreateRect(cv list("M1" "drawing") list(-1.840:0.780 -1.800:0.680))
    shape = dbCreateRect(cv list("M1" "drawing") list(-1.674:0.860 -1.654:0.820))
    shape = dbCreateRect(cv list("M1" "drawing") list(-1.778:1.020 -1.758:0.980))
    shape = dbCreatePolygon(cv list("M1" "drawing") list(-1.820:0.740 -1.540:0.740 -1.540:1.100 -1.716:1.100 -1.716:1.060 -1.580:1.060 -1.580:0.780 -1.820:0.780))
    shape = dbCreateRect(cv list("M1" "drawing") list(-1.812:0.980 -1.620:1.020))
    shape = dbCreateRect(cv list("M1" "drawing") list(-1.812:0.820 -1.620:0.860))
    shape = dbCreateRect(cv list("CT" "drawing") list(-1.820:0.492 -1.612:0.428))
    shape = dbCreateRect(cv list("RVTP" "drawing") list(-1.970:0.920 -1.462:0.278))
    shape = dbCreateRect(cv list("NW" "drawing") list(-1.970:0.920 -1.462:0.278))
    shape = dbCreateRect(cv list("PPLUS" "drawing") list(-1.970:0.920 -1.462:0.278))
    shape = dbCreateRect(cv list("RX" "drawing") list(-1.870:0.780 -1.562:0.580))
    shape = dbCreateRect(cv list("PC" "drawing") list(-1.778:0.920 -1.758:0.378))
    shape = dbCreateRect(cv list("PC" "drawing") list(-1.674:0.920 -1.654:0.378))
    shape = dbCreateRect(cv list("CT" "drawing") list(-1.820:1.412 -1.612:1.348))
    shape = dbCreateRect(cv list("LVTN" "drawing") list(-1.970:1.562 -1.462:0.920))
    shape = dbCreateRect(cv list("NW" "drawing") list(-1.970:1.562 -1.462:0.920))
    shape = dbCreateRect(cv list("NPLUS" "drawing") list(-1.970:1.562 -1.462:0.920))
    shape = dbCreateRect(cv list("RX" "drawing") list(-1.870:1.260 -1.562:1.060))
    shape = dbCreateRect(cv list("PC" "drawing") list(-1.778:1.462 -1.758:0.920))
    shape = dbCreateRect(cv list("PC" "drawing") list(-1.674:1.462 -1.654:0.920))
    shape = dbCreateRect(cv list("M1" "drawing") list(-1.840:0.520 -1.592:0.400))
    shape = dbCreateRect(cv list("M1" "drawing") list(-1.840:1.440 -1.592:1.320))
    shape = dbCreateRect(cv list("CB" "drawing") list(-1.788:1.020 -1.748:0.980))
    shape = dbCreateRect(cv list("CB" "drawing") list(-1.684:0.860 -1.644:0.820))
    shape = dbCreateRect(cv list("CA" "drawing") list(-1.835:0.760 -1.805:0.700))
    shape = dbCreateRect(cv list("CA" "drawing") list(-1.835:1.240 -1.805:1.180))
    shape = dbCreateRect(cv list("M1" "drawing") list(-1.840:1.320 -1.800:1.260))
    shape = dbCreateRect(cv list("CA" "drawing") list(-1.731:1.140 -1.701:1.080))
    shape = dbCreateRect(cv list("CA" "drawing") list(-1.627:0.660 -1.597:0.600))
    shape = dbCreateRect(cv list("M1" "drawing") list(-1.632:0.580 -1.592:0.520))
    shape = dbCreateRect(cv list("CA" "drawing") list(-1.627:1.240 -1.597:1.180))
    shape = dbCreateRect(cv list("M1" "drawing") list(-1.632:1.320 -1.592:1.260))
    shape = dbCreateRect(cv list("CT" "drawing") list(-1.612:0.952 -1.508:0.888))
    shape = dbCreateRect(cv list("RVTP" "drawing") list(-1.762:0.920 -1.358:0.278))
    shape = dbCreateRect(cv list("NW" "drawing") list(-1.762:0.920 -1.358:0.278))
    shape = dbCreateRect(cv list("PPLUS" "drawing") list(-1.762:0.920 -1.358:0.278))
    shape = dbCreateRect(cv list("RX" "drawing") list(-1.662:0.780 -1.458:0.580))
    shape = dbCreateRect(cv list("PC" "drawing") list(-1.570:0.920 -1.550:0.378))
    shape = dbCreateRect(cv list("CT" "drawing") list(-1.612:0.952 -1.508:0.888))
    shape = dbCreateRect(cv list("LVTN" "drawing") list(-1.762:1.562 -1.358:0.920))
    shape = dbCreateRect(cv list("NW" "drawing") list(-1.762:1.562 -1.358:0.920))
    shape = dbCreateRect(cv list("NPLUS" "drawing") list(-1.762:1.562 -1.358:0.920))
    shape = dbCreateRect(cv list("RX" "drawing") list(-1.662:1.260 -1.458:1.060))
    shape = dbCreateRect(cv list("PC" "drawing") list(-1.570:1.462 -1.550:0.920))
    shape = dbCreateRect(cv list("M1" "drawing") list(-1.632:0.520 -1.488:0.400))
    shape = dbCreateRect(cv list("M1" "drawing") list(-1.632:1.440 -1.488:1.320))
    shape = dbCreateRect(cv list("CB" "drawing") list(-1.580:0.480 -1.540:0.440))
    shape = dbCreateRect(cv list("CB" "drawing") list(-1.580:1.400 -1.540:1.360))
    shape = dbCreateRect(cv list("M1" "drawing") list(-1.424:1.160 -1.384:1.060))
    shape = dbCreateRect(cv list("M1" "drawing") list(-1.424:0.780 -1.384:0.680))
    shape = dbCreateRect(cv list("M1" "drawing") list(-1.528:1.260 -1.488:1.160))
    shape = dbCreateRect(cv list("M1" "drawing") list(-1.528:0.680 -1.488:0.580))
    shape = dbCreateRect(cv list("M1" "drawing") list(-1.466:0.940 -1.446:0.900))
    shape = dbCreatePolygon(cv list("M1" "drawing") list(-1.404:0.740 -1.332:0.740 -1.332:1.100 -1.404:1.100 -1.404:1.060 -1.372:1.060 -1.372:0.780 -1.404:0.780))
    shape = dbCreateRect(cv list("CT" "drawing") list(-1.508:0.492 -1.404:0.428))
    shape = dbCreateRect(cv list("RVTP" "drawing") list(-1.658:0.920 -1.254:0.278))
    shape = dbCreateRect(cv list("NW" "drawing") list(-1.658:0.920 -1.254:0.278))
    shape = dbCreateRect(cv list("PPLUS" "drawing") list(-1.658:0.920 -1.254:0.278))
    shape = dbCreateRect(cv list("RX" "drawing") list(-1.558:0.780 -1.354:0.580))
    shape = dbCreateRect(cv list("PC" "drawing") list(-1.466:0.920 -1.446:0.378))
    shape = dbCreateRect(cv list("CT" "drawing") list(-1.508:1.412 -1.404:1.348))
    shape = dbCreateRect(cv list("LVTN" "drawing") list(-1.658:1.562 -1.254:0.920))
    shape = dbCreateRect(cv list("NW" "drawing") list(-1.658:1.562 -1.254:0.920))
    shape = dbCreateRect(cv list("NPLUS" "drawing") list(-1.658:1.562 -1.254:0.920))
    shape = dbCreateRect(cv list("RX" "drawing") list(-1.558:1.260 -1.354:1.060))
    shape = dbCreateRect(cv list("PC" "drawing") list(-1.466:1.462 -1.446:0.920))
    shape = dbCreateRect(cv list("M1" "drawing") list(-1.528:0.520 -1.384:0.400))
    shape = dbCreateRect(cv list("M1" "drawing") list(-1.528:1.440 -1.384:1.320))
    shape = dbCreateRect(cv list("CB" "drawing") list(-1.476:0.940 -1.436:0.900))
    shape = dbCreateRect(cv list("CA" "drawing") list(-1.523:0.660 -1.493:0.600))
    shape = dbCreateRect(cv list("M1" "drawing") list(-1.528:0.580 -1.488:0.520))
    shape = dbCreateRect(cv list("CA" "drawing") list(-1.523:1.240 -1.493:1.180))
    shape = dbCreateRect(cv list("M1" "drawing") list(-1.528:1.320 -1.488:1.260))
    shape = dbCreateRect(cv list("CA" "drawing") list(-1.419:0.760 -1.389:0.700))
    shape = dbCreateRect(cv list("CA" "drawing") list(-1.419:1.140 -1.389:1.080))
    shape = dbCreateRect(cv list("M1" "drawing") list(-1.560:0.900 -1.412:0.940))
    shape = dbCreateRect(cv list("CT" "drawing") list(-1.924:0.952 -1.820:0.888))
    shape = dbCreateRect(cv list("RVTP" "drawing") list(-2.074:0.920 -1.670:0.278))
    shape = dbCreateRect(cv list("NW" "drawing") list(-2.074:0.920 -1.670:0.278))
    shape = dbCreateRect(cv list("PPLUS" "drawing") list(-2.074:0.920 -1.670:0.278))
    shape = dbCreateRect(cv list("RX" "drawing") list(-1.974:0.780 -1.770:0.580))
    shape = dbCreateRect(cv list("PC" "drawing") list(-1.882:0.920 -1.862:0.378))
    shape = dbCreateRect(cv list("CT" "drawing") list(-1.924:0.952 -1.820:0.888))
    shape = dbCreateRect(cv list("LVTN" "drawing") list(-2.074:1.562 -1.670:0.920))
    shape = dbCreateRect(cv list("NW" "drawing") list(-2.074:1.562 -1.670:0.920))
    shape = dbCreateRect(cv list("NPLUS" "drawing") list(-2.074:1.562 -1.670:0.920))
    shape = dbCreateRect(cv list("RX" "drawing") list(-1.974:1.260 -1.770:1.060))
    shape = dbCreateRect(cv list("PC" "drawing") list(-1.882:1.462 -1.862:0.920))
    shape = dbCreateRect(cv list("M1" "drawing") list(-1.944:0.520 -1.800:0.400))
    shape = dbCreateRect(cv list("M1" "drawing") list(-1.944:1.440 -1.800:1.320))
    shape = dbCreateRect(cv list("CB" "drawing") list(-1.892:0.480 -1.852:0.440))
    shape = dbCreateRect(cv list("CB" "drawing") list(-1.892:1.400 -1.852:1.360))
    shape = dbCreateRect(cv list("M1" "drawing") list(-1.944:1.160 -1.904:1.060))
    shape = dbCreateRect(cv list("M1" "drawing") list(-1.944:0.780 -1.904:0.680))
    shape = dbCreateRect(cv list("M1" "drawing") list(-2.048:1.260 -2.008:1.160))
    shape = dbCreateRect(cv list("M1" "drawing") list(-2.048:0.680 -2.008:0.580))
    shape = dbCreateRect(cv list("M1" "drawing") list(-1.986:0.940 -1.966:0.900))
    shape = dbCreatePolygon(cv list("M1" "drawing") list(-1.904:0.760 -1.904:1.080 -1.944:1.080 -1.944:0.760))
    shape = dbCreateRect(cv list("CT" "drawing") list(-2.028:0.492 -1.924:0.428))
    shape = dbCreateRect(cv list("RVTP" "drawing") list(-2.178:0.920 -1.774:0.278))
    shape = dbCreateRect(cv list("NW" "drawing") list(-2.178:0.920 -1.774:0.278))
    shape = dbCreateRect(cv list("PPLUS" "drawing") list(-2.178:0.920 -1.774:0.278))
    shape = dbCreateRect(cv list("RX" "drawing") list(-2.078:0.780 -1.874:0.580))
    shape = dbCreateRect(cv list("PC" "drawing") list(-1.986:0.920 -1.966:0.378))
    shape = dbCreateRect(cv list("CT" "drawing") list(-2.028:1.412 -1.924:1.348))
    shape = dbCreateRect(cv list("LVTN" "drawing") list(-2.178:1.562 -1.774:0.920))
    shape = dbCreateRect(cv list("NW" "drawing") list(-2.178:1.562 -1.774:0.920))
    shape = dbCreateRect(cv list("NPLUS" "drawing") list(-2.178:1.562 -1.774:0.920))
    shape = dbCreateRect(cv list("RX" "drawing") list(-2.078:1.260 -1.874:1.060))
    shape = dbCreateRect(cv list("PC" "drawing") list(-1.986:1.462 -1.966:0.920))
    shape = dbCreateRect(cv list("M1" "drawing") list(-2.048:0.520 -1.904:0.400))
    shape = dbCreateRect(cv list("M1" "drawing") list(-2.048:1.440 -1.904:1.320))
    shape = dbCreateRect(cv list("CB" "drawing") list(-1.996:0.940 -1.956:0.900))
    shape = dbCreateRect(cv list("CA" "drawing") list(-2.043:0.660 -2.013:0.600))
    shape = dbCreateRect(cv list("M1" "drawing") list(-2.048:0.580 -2.008:0.520))
    shape = dbCreateRect(cv list("CA" "drawing") list(-2.043:1.240 -2.013:1.180))
    shape = dbCreateRect(cv list("M1" "drawing") list(-2.048:1.320 -2.008:1.260))
    shape = dbCreateRect(cv list("CA" "drawing") list(-1.939:0.760 -1.909:0.700))
    shape = dbCreateRect(cv list("CA" "drawing") list(-1.939:1.140 -1.909:1.080))
    shape = dbCreateRect(cv list("CT" "drawing") list(-2.132:0.952 -2.028:0.888))
    shape = dbCreateRect(cv list("RVTP" "drawing") list(-2.282:0.920 -1.878:0.278))
    shape = dbCreateRect(cv list("NW" "drawing") list(-2.282:0.920 -1.878:0.278))
    shape = dbCreateRect(cv list("PPLUS" "drawing") list(-2.282:0.920 -1.878:0.278))
    shape = dbCreateRect(cv list("RX" "drawing") list(-2.182:0.780 -1.978:0.580))
    shape = dbCreateRect(cv list("PC" "drawing") list(-2.090:0.920 -2.070:0.378))
    shape = dbCreateRect(cv list("CT" "drawing") list(-2.132:0.952 -2.028:0.888))
    shape = dbCreateRect(cv list("LVTN" "drawing") list(-2.282:1.562 -1.878:0.920))
    shape = dbCreateRect(cv list("NW" "drawing") list(-2.282:1.562 -1.878:0.920))
    shape = dbCreateRect(cv list("NPLUS" "drawing") list(-2.282:1.562 -1.878:0.920))
    shape = dbCreateRect(cv list("RX" "drawing") list(-2.182:1.260 -1.978:1.060))
    shape = dbCreateRect(cv list("PC" "drawing") list(-2.090:1.462 -2.070:0.920))
    shape = dbCreateRect(cv list("M1" "drawing") list(-2.152:0.520 -2.008:0.400))
    shape = dbCreateRect(cv list("M1" "drawing") list(-2.152:1.440 -2.008:1.320))
    shape = dbCreateRect(cv list("CB" "drawing") list(-2.100:0.480 -2.060:0.440))
    shape = dbCreateRect(cv list("CB" "drawing") list(-2.100:1.400 -2.060:1.360))
    shape = dbCreatePolygon(cv list("M1" "drawing") list(-2.412:0.920 -2.412:0.820 -2.184:0.820 -2.184:0.860 -2.372:0.860 -2.372:0.920))
    shape = dbCreateRect(cv list("M1" "drawing") list(-2.152:1.320 -2.112:1.260))
    shape = dbCreateRect(cv list("CA" "drawing") list(-2.147:1.240 -2.117:1.180))
    shape = dbCreateRect(cv list("M1" "drawing") list(-2.152:0.580 -2.112:0.520))
    shape = dbCreateRect(cv list("CA" "drawing") list(-2.147:0.660 -2.117:0.600))
    shape = dbCreateRect(cv list("CA" "drawing") list(-2.251:0.760 -2.221:0.700))
    shape = dbCreateRect(cv list("CA" "drawing") list(-2.355:1.140 -2.325:1.080))
    shape = dbCreateRect(cv list("M1" "drawing") list(-2.360:0.580 -2.320:0.520))
    shape = dbCreateRect(cv list("CA" "drawing") list(-2.355:0.660 -2.325:0.600))
    shape = dbCreateRect(cv list("CB" "drawing") list(-2.204:0.860 -2.164:0.820))
    shape = dbCreateRect(cv list("CB" "drawing") list(-2.308:1.020 -2.268:0.980))
    shape = dbCreateRect(cv list("M1" "drawing") list(-2.360:1.440 -2.112:1.320))
    shape = dbCreateRect(cv list("M1" "drawing") list(-2.360:0.520 -2.112:0.400))
    shape = dbCreateRect(cv list("PC" "drawing") list(-2.194:1.462 -2.174:0.920))
    shape = dbCreateRect(cv list("PC" "drawing") list(-2.298:1.462 -2.278:0.920))
    shape = dbCreateRect(cv list("RX" "drawing") list(-2.390:1.260 -2.082:1.060))
    shape = dbCreateRect(cv list("NPLUS" "drawing") list(-2.490:1.562 -1.982:0.920))
    shape = dbCreateRect(cv list("NW" "drawing") list(-2.490:1.562 -1.982:0.920))
    shape = dbCreateRect(cv list("LVTN" "drawing") list(-2.490:1.562 -1.982:0.920))
    shape = dbCreateRect(cv list("CT" "drawing") list(-2.340:1.412 -2.132:1.348))
    shape = dbCreateRect(cv list("PC" "drawing") list(-2.194:0.920 -2.174:0.378))
    shape = dbCreateRect(cv list("PC" "drawing") list(-2.298:0.920 -2.278:0.378))
    shape = dbCreateRect(cv list("RX" "drawing") list(-2.390:0.780 -2.082:0.580))
    shape = dbCreateRect(cv list("PPLUS" "drawing") list(-2.490:0.920 -1.982:0.278))
    shape = dbCreateRect(cv list("NW" "drawing") list(-2.490:0.920 -1.982:0.278))
    shape = dbCreateRect(cv list("RVTP" "drawing") list(-2.490:0.920 -1.982:0.278))
    shape = dbCreateRect(cv list("CT" "drawing") list(-2.340:0.492 -2.132:0.428))
    shape = dbCreateRect(cv list("M1" "drawing") list(-2.332:0.820 -2.140:0.860))
    shape = dbCreateRect(cv list("M1" "drawing") list(-2.332:0.980 -2.140:1.020))
    shape = dbCreatePolygon(cv list("M1" "drawing") list(-2.340:1.060 -2.100:1.060 -2.100:0.780 -2.236:0.780 -2.236:0.740 -2.060:0.740 -2.060:1.100 -2.340:1.100))
    shape = dbCreateRect(cv list("M1" "drawing") list(-2.298:1.020 -2.278:0.980))
    shape = dbCreateRect(cv list("M1" "drawing") list(-2.194:0.860 -2.174:0.820))
    shape = dbCreateRect(cv list("M1" "drawing") list(-2.360:0.680 -2.320:0.580))
    shape = dbCreateRect(cv list("M1" "drawing") list(-2.360:1.160 -2.320:1.060))
    shape = dbCreateRect(cv list("M1" "drawing") list(-2.256:0.780 -2.216:0.680))
    shape = dbCreateRect(cv list("M1" "drawing") list(-2.152:0.680 -2.112:0.580))
    shape = dbCreateRect(cv list("M1" "drawing") list(-2.152:1.260 -2.112:1.160))
    shape = dbCreateRect(cv list("M1" "drawing") list(-2.672:1.260 -2.632:1.160))
    shape = dbCreateRect(cv list("M1" "drawing") list(-2.672:0.680 -2.632:0.580))
    shape = dbCreateRect(cv list("M1" "drawing") list(-2.776:1.160 -2.736:1.060))
    shape = dbCreateRect(cv list("M1" "drawing") list(-2.880:1.260 -2.840:1.160))
    shape = dbCreateRect(cv list("M1" "drawing") list(-2.880:0.780 -2.840:0.680))
    shape = dbCreateRect(cv list("M1" "drawing") list(-2.714:0.860 -2.694:0.820))
    shape = dbCreateRect(cv list("M1" "drawing") list(-2.818:1.020 -2.798:0.980))
    shape = dbCreatePolygon(cv list("M1" "drawing") list(-2.860:0.740 -2.580:0.740 -2.580:1.100 -2.756:1.100 -2.756:1.060 -2.620:1.060 -2.620:0.780 -2.860:0.780))
    shape = dbCreateRect(cv list("M1" "drawing") list(-2.852:0.980 -2.660:1.020))
    shape = dbCreateRect(cv list("M1" "drawing") list(-2.852:0.820 -2.660:0.860))
    shape = dbCreateRect(cv list("CT" "drawing") list(-2.860:0.492 -2.652:0.428))
    shape = dbCreateRect(cv list("RVTP" "drawing") list(-3.010:0.920 -2.502:0.278))
    shape = dbCreateRect(cv list("NW" "drawing") list(-3.010:0.920 -2.502:0.278))
    shape = dbCreateRect(cv list("PPLUS" "drawing") list(-3.010:0.920 -2.502:0.278))
    shape = dbCreateRect(cv list("RX" "drawing") list(-2.910:0.780 -2.602:0.580))
    shape = dbCreateRect(cv list("PC" "drawing") list(-2.818:0.920 -2.798:0.378))
    shape = dbCreateRect(cv list("PC" "drawing") list(-2.714:0.920 -2.694:0.378))
    shape = dbCreateRect(cv list("CT" "drawing") list(-2.860:1.412 -2.652:1.348))
    shape = dbCreateRect(cv list("LVTN" "drawing") list(-3.010:1.562 -2.502:0.920))
    shape = dbCreateRect(cv list("NW" "drawing") list(-3.010:1.562 -2.502:0.920))
    shape = dbCreateRect(cv list("NPLUS" "drawing") list(-3.010:1.562 -2.502:0.920))
    shape = dbCreateRect(cv list("RX" "drawing") list(-2.910:1.260 -2.602:1.060))
    shape = dbCreateRect(cv list("PC" "drawing") list(-2.818:1.462 -2.798:0.920))
    shape = dbCreateRect(cv list("PC" "drawing") list(-2.714:1.462 -2.694:0.920))
    shape = dbCreateRect(cv list("M1" "drawing") list(-2.880:0.520 -2.632:0.400))
    shape = dbCreateRect(cv list("M1" "drawing") list(-2.880:1.440 -2.632:1.320))
    shape = dbCreateRect(cv list("CB" "drawing") list(-2.828:1.020 -2.788:0.980))
    shape = dbCreateRect(cv list("CB" "drawing") list(-2.724:0.860 -2.684:0.820))
    shape = dbCreateRect(cv list("CA" "drawing") list(-2.875:0.760 -2.845:0.700))
    shape = dbCreateRect(cv list("CA" "drawing") list(-2.875:1.240 -2.845:1.180))
    shape = dbCreateRect(cv list("M1" "drawing") list(-2.880:1.320 -2.840:1.260))
    shape = dbCreateRect(cv list("CA" "drawing") list(-2.771:1.140 -2.741:1.080))
    shape = dbCreateRect(cv list("CA" "drawing") list(-2.667:0.660 -2.637:0.600))
    shape = dbCreateRect(cv list("M1" "drawing") list(-2.672:0.580 -2.632:0.520))
    shape = dbCreateRect(cv list("CA" "drawing") list(-2.667:1.240 -2.637:1.180))
    shape = dbCreateRect(cv list("M1" "drawing") list(-2.672:1.320 -2.632:1.260))
    shape = dbCreateRect(cv list("CT" "drawing") list(-2.652:0.952 -2.548:0.888))
    shape = dbCreateRect(cv list("RVTP" "drawing") list(-2.802:0.920 -2.398:0.278))
    shape = dbCreateRect(cv list("NW" "drawing") list(-2.802:0.920 -2.398:0.278))
    shape = dbCreateRect(cv list("PPLUS" "drawing") list(-2.802:0.920 -2.398:0.278))
    shape = dbCreateRect(cv list("RX" "drawing") list(-2.702:0.780 -2.498:0.580))
    shape = dbCreateRect(cv list("PC" "drawing") list(-2.610:0.920 -2.590:0.378))
    shape = dbCreateRect(cv list("CT" "drawing") list(-2.652:0.952 -2.548:0.888))
    shape = dbCreateRect(cv list("LVTN" "drawing") list(-2.802:1.562 -2.398:0.920))
    shape = dbCreateRect(cv list("NW" "drawing") list(-2.802:1.562 -2.398:0.920))
    shape = dbCreateRect(cv list("NPLUS" "drawing") list(-2.802:1.562 -2.398:0.920))
    shape = dbCreateRect(cv list("RX" "drawing") list(-2.702:1.260 -2.498:1.060))
    shape = dbCreateRect(cv list("PC" "drawing") list(-2.610:1.462 -2.590:0.920))
    shape = dbCreateRect(cv list("M1" "drawing") list(-2.672:0.520 -2.528:0.400))
    shape = dbCreateRect(cv list("M1" "drawing") list(-2.672:1.440 -2.528:1.320))
    shape = dbCreateRect(cv list("CB" "drawing") list(-2.620:0.480 -2.580:0.440))
    shape = dbCreateRect(cv list("CB" "drawing") list(-2.620:1.400 -2.580:1.360))
    shape = dbCreateRect(cv list("M1" "drawing") list(-2.464:1.160 -2.424:1.060))
    shape = dbCreateRect(cv list("M1" "drawing") list(-2.464:0.780 -2.424:0.680))
    shape = dbCreateRect(cv list("M1" "drawing") list(-2.568:1.260 -2.528:1.160))
    shape = dbCreateRect(cv list("M1" "drawing") list(-2.568:0.680 -2.528:0.580))
    shape = dbCreateRect(cv list("M1" "drawing") list(-2.506:0.940 -2.486:0.900))
    shape = dbCreatePolygon(cv list("M1" "drawing") list(-2.444:0.740 -2.372:0.740 -2.372:1.100 -2.444:1.100 -2.444:1.060 -2.412:1.060 -2.412:0.780 -2.444:0.780))
    shape = dbCreateRect(cv list("CT" "drawing") list(-2.548:0.492 -2.444:0.428))
    shape = dbCreateRect(cv list("RVTP" "drawing") list(-2.698:0.920 -2.294:0.278))
    shape = dbCreateRect(cv list("NW" "drawing") list(-2.698:0.920 -2.294:0.278))
    shape = dbCreateRect(cv list("PPLUS" "drawing") list(-2.698:0.920 -2.294:0.278))
    shape = dbCreateRect(cv list("RX" "drawing") list(-2.598:0.780 -2.394:0.580))
    shape = dbCreateRect(cv list("PC" "drawing") list(-2.506:0.920 -2.486:0.378))
    shape = dbCreateRect(cv list("CT" "drawing") list(-2.548:1.412 -2.444:1.348))
    shape = dbCreateRect(cv list("LVTN" "drawing") list(-2.698:1.562 -2.294:0.920))
    shape = dbCreateRect(cv list("NW" "drawing") list(-2.698:1.562 -2.294:0.920))
    shape = dbCreateRect(cv list("NPLUS" "drawing") list(-2.698:1.562 -2.294:0.920))
    shape = dbCreateRect(cv list("RX" "drawing") list(-2.598:1.260 -2.394:1.060))
    shape = dbCreateRect(cv list("PC" "drawing") list(-2.506:1.462 -2.486:0.920))
    shape = dbCreateRect(cv list("M1" "drawing") list(-2.568:0.520 -2.424:0.400))
    shape = dbCreateRect(cv list("M1" "drawing") list(-2.568:1.440 -2.424:1.320))
    shape = dbCreateRect(cv list("CB" "drawing") list(-2.516:0.940 -2.476:0.900))
    shape = dbCreateRect(cv list("CA" "drawing") list(-2.563:0.660 -2.533:0.600))
    shape = dbCreateRect(cv list("M1" "drawing") list(-2.568:0.580 -2.528:0.520))
    shape = dbCreateRect(cv list("CA" "drawing") list(-2.563:1.240 -2.533:1.180))
    shape = dbCreateRect(cv list("M1" "drawing") list(-2.568:1.320 -2.528:1.260))
    shape = dbCreateRect(cv list("CA" "drawing") list(-2.459:0.760 -2.429:0.700))
    shape = dbCreateRect(cv list("CA" "drawing") list(-2.459:1.140 -2.429:1.080))
    shape = dbCreateRect(cv list("M1" "drawing") list(-2.600:0.900 -2.452:0.940))
    shape = dbCreateRect(cv list("CB" "drawing") list(-2.412:1.400 -2.372:1.360))
    shape = dbCreateRect(cv list("CB" "drawing") list(-2.412:0.480 -2.372:0.440))
    shape = dbCreateRect(cv list("M1" "drawing") list(-2.464:1.440 -2.320:1.320))
    shape = dbCreateRect(cv list("M1" "drawing") list(-2.464:0.520 -2.320:0.400))
    shape = dbCreateRect(cv list("PC" "drawing") list(-2.402:1.462 -2.382:0.920))
    shape = dbCreateRect(cv list("RX" "drawing") list(-2.494:1.260 -2.290:1.060))
    shape = dbCreateRect(cv list("NPLUS" "drawing") list(-2.594:1.562 -2.190:0.920))
    shape = dbCreateRect(cv list("NW" "drawing") list(-2.594:1.562 -2.190:0.920))
    shape = dbCreateRect(cv list("LVTN" "drawing") list(-2.594:1.562 -2.190:0.920))
    shape = dbCreateRect(cv list("CT" "drawing") list(-2.444:0.952 -2.340:0.888))
    shape = dbCreateRect(cv list("PC" "drawing") list(-2.402:0.920 -2.382:0.378))
    shape = dbCreateRect(cv list("RX" "drawing") list(-2.494:0.780 -2.290:0.580))
    shape = dbCreateRect(cv list("PPLUS" "drawing") list(-2.594:0.920 -2.190:0.278))
    shape = dbCreateRect(cv list("NW" "drawing") list(-2.594:0.920 -2.190:0.278))
    shape = dbCreateRect(cv list("RVTP" "drawing") list(-2.594:0.920 -2.190:0.278))
    shape = dbCreateRect(cv list("CT" "drawing") list(-2.444:0.952 -2.340:0.888))
    shape = dbCreateRect(cv list("M2" "drawing") list(-0.010:1.900 0.010:1.940))
    shape = dbCreateRect(cv list("M1" "drawing") list(-0.010:1.900 0.010:1.940))
    shape = dbCreateRect(cv list("M2" "drawing") list(0.104:1.820 0.252:1.860))
    shape = dbCreateRect(cv list("M1" "drawing") list(0.104:1.820 0.252:1.860))
    shape = dbCreateRect(cv list("M2" "drawing") list(0.198:1.660 0.322:1.700))
    shape = dbCreateRect(cv list("M1" "drawing") list(0.198:1.660 0.322:1.700))
    shape = dbCreateRect(cv list("V1" "drawing") list(0.220:1.660 0.300:1.700))
    shape = dbCreateRect(cv list("V1" "drawing") list(0.138:1.820 0.218:1.860))
    shape = dbCreateRect(cv list("V1" "drawing") list(0.629:1.740 0.709:1.780))
    shape = dbCreateRect(cv list("V1" "drawing") list(0.435:1.740 0.515:1.780))
    shape = dbCreateRect(cv list("V1" "drawing") list(1.572:1.820 1.652:1.860))
    shape = dbCreateRect(cv list("V1" "drawing") list(1.624:1.740 1.704:1.780))
    shape = dbCreateRect(cv list("V1" "drawing") list(0.948:1.900 1.028:1.940))
    shape = dbCreateRect(cv list("V1" "drawing") list(0.948:1.740 1.028:1.780))
    shape = dbCreateRect(cv list("V1" "drawing") list(1.260:1.900 1.340:1.940))
    shape = dbCreateRect(cv list("V1" "drawing") list(1.260:1.740 1.340:1.780))
    shape = dbCreateRect(cv list("V1" "drawing") list(0.629:1.900 0.709:1.940))
    shape = dbCreateRect(cv list("V1" "drawing") list(0.435:1.900 0.515:1.940))
    shape = dbCreateRect(cv list("V1" "drawing") list(-0.040:1.900 0.040:1.940))
    shape = dbCreateRect(cv list("M1" "drawing") list(1.840:1.820 1.976:1.860))
    shape = dbCreateRect(cv list("M2" "drawing") list(0.000:1.900 0.668:1.940))
    shape = dbCreateRect(cv list("M1" "drawing") list(0.372:1.900 0.772:1.940))
    shape = dbCreateRect(cv list("M1" "drawing") list(1.204:1.740 1.396:1.780))
    shape = dbCreateRect(cv list("M1" "drawing") list(1.204:1.900 1.396:1.940))
    shape = dbCreateRect(cv list("M1" "drawing") list(0.892:1.740 1.084:1.780))
    shape = dbCreateRect(cv list("M1" "drawing") list(0.892:1.900 1.084:1.940))
    shape = dbCreateRect(cv list("M1" "drawing") list(1.560:1.740 1.768:1.780))
    shape = dbCreatePolygon(cv list("M1" "drawing") list(1.684:1.840 1.684:1.900 1.768:1.900 1.768:1.940 1.644:1.940 1.644:1.840))
    shape = dbCreateRect(cv list("M1" "drawing") list(1.528:1.820 1.696:1.860))
    shape = dbCreateRect(cv list("M1" "drawing") list(0.372:1.740 0.772:1.780))
    shape = dbCreateRect(cv list("M1" "drawing") list(0.312:1.820 0.772:1.860))
    shape = dbCreatePolygon(cv list("M2" "drawing") list(0.104:1.820 0.292:1.820 0.292:1.740 0.852:1.740 0.852:1.900 1.748:1.900 1.748:1.780 1.560:1.780 1.560:1.740 1.788:1.740 1.788:1.940 0.812:1.940 0.812:1.780 0.332:1.780 0.332:1.860 0.104:1.860))
    shape = dbCreatePolygon(cv list("M2" "drawing") list(0.260:1.660 0.956:1.660 0.956:1.740 1.476:1.740 1.476:1.820 1.664:1.820 1.664:1.860 1.436:1.860 1.436:1.780 0.916:1.780 0.916:1.700 0.260:1.700))
    shape = dbCreateRect(cv list("M1" "drawing") list(1.456:1.900 1.614:1.940))
    shape = dbCreatePolygon(cv list("M1" "drawing") list(1.612:1.500 1.840:1.500 1.840:1.660 1.892:1.660 1.892:1.840 1.852:1.840 1.852:1.700 1.800:1.700 1.800:1.540 1.612:1.540))
    shape = dbCreatePolygon(cv list("M1" "drawing") list(1.612:2.140 1.800:2.140 1.800:1.980 1.852:1.980 1.852:1.840 1.892:1.840 1.892:2.020 1.840:2.020 1.840:2.180 1.612:2.180))
    shape = dbCreatePolygon(cv list("M1" "drawing") list(0.884:1.530 1.112:1.530 1.112:1.660 1.164:1.660 1.164:1.840 1.124:1.840 1.124:1.700 1.072:1.700 1.072:1.570 0.884:1.570))
    shape = dbCreatePolygon(cv list("M1" "drawing") list(0.884:2.110 1.072:2.110 1.072:1.980 1.124:1.980 1.124:1.840 1.164:1.840 1.164:2.020 1.112:2.020 1.112:2.150 0.884:2.150))
    shape = dbCreateRect(cv list("M1" "drawing") list(2.080:1.820 2.184:1.860))
    shape = dbCreateRect(cv list("CA" "drawing") list(2.221:1.620 2.251:1.680))
    shape = dbCreateRect(cv list("CA" "drawing") list(2.221:2.000 2.251:2.060))
    shape = dbCreateRect(cv list("M1" "drawing") list(2.112:1.440 2.152:1.500))
    shape = dbCreateRect(cv list("CA" "drawing") list(2.117:1.520 2.147:1.580))
    shape = dbCreateRect(cv list("M1" "drawing") list(2.112:2.180 2.152:2.240))
    shape = dbCreateRect(cv list("CA" "drawing") list(2.117:2.100 2.147:2.160))
    shape = dbCreateRect(cv list("CB" "drawing") list(2.164:1.820 2.204:1.860))
    shape = dbCreateRect(cv list("M1" "drawing") list(2.112:1.320 2.256:1.440))
    shape = dbCreateRect(cv list("M1" "drawing") list(2.112:2.240 2.256:2.360))
    shape = dbCreateRect(cv list("PC" "drawing") list(2.174:1.298 2.194:1.840))
    shape = dbCreateRect(cv list("RX" "drawing") list(2.082:1.500 2.286:1.700))
    shape = dbCreateRect(cv list("NPLUS" "drawing") list(1.982:1.198 2.386:1.840))
    shape = dbCreateRect(cv list("NW" "drawing") list(1.982:1.198 2.386:1.840))
    shape = dbCreateRect(cv list("LVTN" "drawing") list(1.982:1.198 2.386:1.840))
    shape = dbCreateRect(cv list("CT" "drawing") list(2.132:1.348 2.236:1.412))
    shape = dbCreateRect(cv list("PC" "drawing") list(2.174:1.840 2.194:2.382))
    shape = dbCreateRect(cv list("RX" "drawing") list(2.082:1.980 2.286:2.180))
    shape = dbCreateRect(cv list("PPLUS" "drawing") list(1.982:1.840 2.386:2.482))
    shape = dbCreateRect(cv list("NW" "drawing") list(1.982:1.840 2.386:2.482))
    shape = dbCreateRect(cv list("RVTP" "drawing") list(1.982:1.840 2.386:2.482))
    shape = dbCreateRect(cv list("CT" "drawing") list(2.132:2.268 2.236:2.332))
    shape = dbCreatePolygon(cv list("M1" "drawing") list(2.236:1.980 2.268:1.980 2.268:1.700 2.236:1.700 2.236:1.660 2.308:1.660 2.308:2.020 2.236:2.020))
    shape = dbCreateRect(cv list("M1" "drawing") list(2.174:1.820 2.194:1.860))
    shape = dbCreateRect(cv list("M1" "drawing") list(2.112:2.080 2.152:2.180))
    shape = dbCreateRect(cv list("M1" "drawing") list(2.112:1.500 2.152:1.600))
    shape = dbCreateRect(cv list("M1" "drawing") list(2.216:1.980 2.256:2.080))
    shape = dbCreateRect(cv list("M1" "drawing") list(2.216:1.600 2.256:1.700))
    shape = dbCreateRect(cv list("CA" "drawing") list(2.013:1.620 2.043:1.680))
    shape = dbCreateRect(cv list("CA" "drawing") list(2.013:2.000 2.043:2.060))
    shape = dbCreateRect(cv list("M1" "drawing") list(1.904:1.440 1.944:1.500))
    shape = dbCreateRect(cv list("CA" "drawing") list(1.909:1.520 1.939:1.580))
    shape = dbCreateRect(cv list("M1" "drawing") list(1.904:2.180 1.944:2.240))
    shape = dbCreateRect(cv list("CA" "drawing") list(1.909:2.100 1.939:2.160))
    shape = dbCreateRect(cv list("M1" "drawing") list(2.112:1.440 2.152:1.500))
    shape = dbCreateRect(cv list("M1" "drawing") list(2.112:2.180 2.152:2.240))
    shape = dbCreateRect(cv list("CA" "drawing") list(2.117:1.520 2.147:1.580))
    shape = dbCreateRect(cv list("CA" "drawing") list(2.117:2.100 2.147:2.160))
    shape = dbCreateRect(cv list("CB" "drawing") list(2.060:1.360 2.100:1.400))
    shape = dbCreateRect(cv list("CB" "drawing") list(2.060:2.280 2.100:2.320))
    shape = dbCreateRect(cv list("CB" "drawing") list(1.956:1.820 1.996:1.860))
    shape = dbCreateRect(cv list("M1" "drawing") list(1.904:1.320 2.152:1.440))
    shape = dbCreateRect(cv list("M1" "drawing") list(1.904:2.240 2.152:2.360))
    shape = dbCreateRect(cv list("PC" "drawing") list(2.070:1.298 2.090:1.840))
    shape = dbCreateRect(cv list("RX" "drawing") list(1.978:1.500 2.182:1.700))
    shape = dbCreateRect(cv list("NPLUS" "drawing") list(1.878:1.198 2.282:1.840))
    shape = dbCreateRect(cv list("NW" "drawing") list(1.878:1.198 2.282:1.840))
    shape = dbCreateRect(cv list("LVTN" "drawing") list(1.878:1.198 2.282:1.840))
    shape = dbCreateRect(cv list("CT" "drawing") list(2.028:1.808 2.132:1.872))
    shape = dbCreateRect(cv list("PC" "drawing") list(1.966:1.298 1.986:1.840))
    shape = dbCreateRect(cv list("RX" "drawing") list(1.874:1.500 2.078:1.700))
    shape = dbCreateRect(cv list("NPLUS" "drawing") list(1.774:1.198 2.178:1.840))
    shape = dbCreateRect(cv list("NW" "drawing") list(1.774:1.198 2.178:1.840))
    shape = dbCreateRect(cv list("LVTN" "drawing") list(1.774:1.198 2.178:1.840))
    shape = dbCreateRect(cv list("CT" "drawing") list(1.924:1.348 2.028:1.412))
    shape = dbCreateRect(cv list("PC" "drawing") list(2.070:1.840 2.090:2.382))
    shape = dbCreateRect(cv list("RX" "drawing") list(1.978:1.980 2.182:2.180))
    shape = dbCreateRect(cv list("PPLUS" "drawing") list(1.878:1.840 2.282:2.482))
    shape = dbCreateRect(cv list("NW" "drawing") list(1.878:1.840 2.282:2.482))
    shape = dbCreateRect(cv list("RVTP" "drawing") list(1.878:1.840 2.282:2.482))
    shape = dbCreateRect(cv list("CT" "drawing") list(2.028:1.808 2.132:1.872))
    shape = dbCreateRect(cv list("PC" "drawing") list(1.966:1.840 1.986:2.382))
    shape = dbCreateRect(cv list("RX" "drawing") list(1.874:1.980 2.078:2.180))
    shape = dbCreateRect(cv list("PPLUS" "drawing") list(1.774:1.840 2.178:2.482))
    shape = dbCreateRect(cv list("NW" "drawing") list(1.774:1.840 2.178:2.482))
    shape = dbCreateRect(cv list("RVTP" "drawing") list(1.774:1.840 2.178:2.482))
    shape = dbCreateRect(cv list("CT" "drawing") list(1.924:2.268 2.028:2.332))
    shape = dbCreatePolygon(cv list("M1" "drawing") list(2.028:1.980 2.060:1.980 2.060:1.700 2.028:1.700 2.028:1.660 2.100:1.660 2.100:2.020 2.028:2.020))
    shape = dbCreateRect(cv list("M1" "drawing") list(1.966:1.820 1.986:1.860))
    shape = dbCreateRect(cv list("M1" "drawing") list(2.112:2.080 2.152:2.180))
    shape = dbCreateRect(cv list("M1" "drawing") list(2.112:1.500 2.152:1.600))
    shape = dbCreateRect(cv list("M1" "drawing") list(1.904:2.080 1.944:2.180))
    shape = dbCreateRect(cv list("M1" "drawing") list(1.904:1.500 1.944:1.600))
    shape = dbCreateRect(cv list("M1" "drawing") list(2.008:1.980 2.048:2.080))
    shape = dbCreateRect(cv list("M1" "drawing") list(2.008:1.600 2.048:1.700))
    shape = dbCreateRect(cv list("CA" "drawing") list(1.701:1.620 1.731:1.680))
    shape = dbCreateRect(cv list("CA" "drawing") list(1.701:2.000 1.731:2.060))
    shape = dbCreateRect(cv list("M1" "drawing") list(1.904:1.440 1.944:1.500))
    shape = dbCreateRect(cv list("CA" "drawing") list(1.909:1.520 1.939:1.580))
    shape = dbCreateRect(cv list("M1" "drawing") list(1.904:2.180 1.944:2.240))
    shape = dbCreateRect(cv list("CA" "drawing") list(1.909:2.100 1.939:2.160))
    shape = dbCreateRect(cv list("PC" "drawing") list(1.758:1.380 1.778:1.840))
    shape = dbCreateRect(cv list("RX" "drawing") list(1.666:1.500 1.870:1.700))
    shape = dbCreateRect(cv list("NPLUS" "drawing") list(1.566:1.280 1.970:1.840))
    shape = dbCreateRect(cv list("NW" "drawing") list(1.566:1.280 1.970:1.840))
    shape = dbCreateRect(cv list("LVTN" "drawing") list(1.566:1.280 1.970:1.840))
    shape = dbCreateRect(cv list("CT" "drawing") list(1.716:1.808 1.820:1.872))
    shape = dbCreateRect(cv list("PC" "drawing") list(1.758:1.840 1.778:2.300))
    shape = dbCreateRect(cv list("RX" "drawing") list(1.666:1.980 1.870:2.180))
    shape = dbCreateRect(cv list("PPLUS" "drawing") list(1.566:1.840 1.970:2.400))
    shape = dbCreateRect(cv list("NW" "drawing") list(1.566:1.840 1.970:2.400))
    shape = dbCreateRect(cv list("RVTP" "drawing") list(1.566:1.840 1.970:2.400))
    shape = dbCreateRect(cv list("CT" "drawing") list(1.716:1.808 1.820:1.872))
    shape = dbCreateRect(cv list("CB" "drawing") list(1.748:1.740 1.788:1.780))
    shape = dbCreateRect(cv list("CB" "drawing") list(1.748:1.900 1.788:1.940))
    shape = dbCreateRect(cv list("CB" "drawing") list(1.852:1.820 1.892:1.860))
    shape = dbCreateRect(cv list("M1" "drawing") list(1.696:1.320 1.944:1.440))
    shape = dbCreateRect(cv list("M1" "drawing") list(1.696:2.240 1.944:2.360))
    shape = dbCreateRect(cv list("PC" "drawing") list(1.758:1.298 1.778:1.840))
    shape = dbCreateRect(cv list("PC" "drawing") list(1.862:1.298 1.882:1.840))
    shape = dbCreateRect(cv list("RX" "drawing") list(1.666:1.500 1.974:1.700))
    shape = dbCreateRect(cv list("NPLUS" "drawing") list(1.566:1.198 2.074:1.840))
    shape = dbCreateRect(cv list("NW" "drawing") list(1.566:1.198 2.074:1.840))
    shape = dbCreateRect(cv list("LVTN" "drawing") list(1.566:1.198 2.074:1.840))
    shape = dbCreateRect(cv list("CT" "drawing") list(1.716:1.348 1.924:1.412))
    shape = dbCreateRect(cv list("PC" "drawing") list(1.758:1.840 1.778:2.382))
    shape = dbCreateRect(cv list("PC" "drawing") list(1.862:1.840 1.882:2.382))
    shape = dbCreateRect(cv list("RX" "drawing") list(1.666:1.980 1.974:2.180))
    shape = dbCreateRect(cv list("PPLUS" "drawing") list(1.566:1.840 2.074:2.482))
    shape = dbCreateRect(cv list("NW" "drawing") list(1.566:1.840 2.074:2.482))
    shape = dbCreateRect(cv list("RVTP" "drawing") list(1.566:1.840 2.074:2.482))
    shape = dbCreateRect(cv list("CT" "drawing") list(1.716:2.268 1.924:2.332))
    shape = dbCreatePolygon(cv list("M1" "drawing") list(1.716:2.020 1.436:2.020 1.436:1.660 1.716:1.660 1.716:1.700 1.476:1.700 1.476:1.980 1.716:1.980))
    shape = dbCreateRect(cv list("M1" "drawing") list(1.862:1.820 1.882:1.860))
    shape = dbCreateRect(cv list("M1" "drawing") list(1.758:1.900 1.778:1.940))
    shape = dbCreateRect(cv list("M1" "drawing") list(1.758:1.740 1.778:1.780))
    shape = dbCreateRect(cv list("M1" "drawing") list(1.904:2.080 1.944:2.180))
    shape = dbCreateRect(cv list("M1" "drawing") list(1.904:1.500 1.944:1.600))
    shape = dbCreateRect(cv list("M1" "drawing") list(1.696:1.980 1.736:2.080))
    shape = dbCreateRect(cv list("M1" "drawing") list(1.696:1.600 1.736:1.700))
    shape = dbCreateRect(cv list("CB" "drawing") list(1.644:1.360 1.684:1.400))
    shape = dbCreateRect(cv list("CB" "drawing") list(1.644:2.280 1.684:2.320))
    shape = dbCreateRect(cv list("M1" "drawing") list(1.592:1.320 1.736:1.440))
    shape = dbCreateRect(cv list("M1" "drawing") list(1.592:2.240 1.736:2.360))
    shape = dbCreateRect(cv list("PC" "drawing") list(1.654:1.298 1.674:1.840))
    shape = dbCreateRect(cv list("RX" "drawing") list(1.562:1.500 1.766:1.700))
    shape = dbCreateRect(cv list("NPLUS" "drawing") list(1.462:1.198 1.866:1.840))
    shape = dbCreateRect(cv list("NW" "drawing") list(1.462:1.198 1.866:1.840))
    shape = dbCreateRect(cv list("LVTN" "drawing") list(1.462:1.198 1.866:1.840))
    shape = dbCreateRect(cv list("CT" "drawing") list(1.612:1.808 1.716:1.872))
    shape = dbCreateRect(cv list("PC" "drawing") list(1.654:1.840 1.674:2.382))
    shape = dbCreateRect(cv list("RX" "drawing") list(1.562:1.980 1.766:2.180))
    shape = dbCreateRect(cv list("PPLUS" "drawing") list(1.462:1.840 1.866:2.482))
    shape = dbCreateRect(cv list("NW" "drawing") list(1.462:1.840 1.866:2.482))
    shape = dbCreateRect(cv list("RVTP" "drawing") list(1.462:1.840 1.866:2.482))
    shape = dbCreateRect(cv list("CT" "drawing") list(1.612:1.808 1.716:1.872))
    shape = dbCreateRect(cv list("CA" "drawing") list(1.597:1.520 1.627:1.580))
    shape = dbCreateRect(cv list("CA" "drawing") list(1.597:2.100 1.627:2.160))
    shape = dbCreateRect(cv list("M1" "drawing") list(1.488:1.440 1.528:1.500))
    shape = dbCreateRect(cv list("CA" "drawing") list(1.493:1.520 1.523:1.580))
    shape = dbCreateRect(cv list("M1" "drawing") list(1.488:2.180 1.528:2.240))
    shape = dbCreateRect(cv list("CA" "drawing") list(1.493:2.100 1.523:2.160))
    shape = dbCreateRect(cv list("CB" "drawing") list(1.540:1.900 1.580:1.940))
    shape = dbCreateRect(cv list("M1" "drawing") list(1.488:1.320 1.632:1.440))
    shape = dbCreateRect(cv list("M1" "drawing") list(1.488:2.240 1.632:2.360))
    shape = dbCreateRect(cv list("PC" "drawing") list(1.550:1.298 1.570:1.840))
    shape = dbCreateRect(cv list("RX" "drawing") list(1.458:1.500 1.662:1.700))
    shape = dbCreateRect(cv list("NPLUS" "drawing") list(1.358:1.198 1.762:1.840))
    shape = dbCreateRect(cv list("NW" "drawing") list(1.358:1.198 1.762:1.840))
    shape = dbCreateRect(cv list("LVTN" "drawing") list(1.358:1.198 1.762:1.840))
    shape = dbCreateRect(cv list("CT" "drawing") list(1.508:1.348 1.612:1.412))
    shape = dbCreateRect(cv list("PC" "drawing") list(1.550:1.840 1.570:2.382))
    shape = dbCreateRect(cv list("RX" "drawing") list(1.458:1.980 1.662:2.180))
    shape = dbCreateRect(cv list("PPLUS" "drawing") list(1.358:1.840 1.762:2.482))
    shape = dbCreateRect(cv list("NW" "drawing") list(1.358:1.840 1.762:2.482))
    shape = dbCreateRect(cv list("RVTP" "drawing") list(1.358:1.840 1.762:2.482))
    shape = dbCreateRect(cv list("CT" "drawing") list(1.508:2.268 1.612:2.332))
    shape = dbCreateRect(cv list("M1" "drawing") list(1.550:1.900 1.570:1.940))
    shape = dbCreateRect(cv list("M1" "drawing") list(1.488:2.080 1.528:2.180))
    shape = dbCreateRect(cv list("M1" "drawing") list(1.488:1.500 1.528:1.600))
    shape = dbCreateRect(cv list("M1" "drawing") list(1.592:2.080 1.632:2.180))
    shape = dbCreateRect(cv list("M1" "drawing") list(1.592:1.500 1.632:1.600))
    shape = dbCreateRect(cv list("CA" "drawing") list(1.389:1.620 1.419:1.680))
    shape = dbCreateRect(cv list("CA" "drawing") list(1.389:2.000 1.419:2.060))
    shape = dbCreateRect(cv list("CA" "drawing") list(1.285:1.520 1.315:1.580))
    shape = dbCreateRect(cv list("CA" "drawing") list(1.285:2.100 1.315:2.160))
    shape = dbCreateRect(cv list("M1" "drawing") list(1.488:1.440 1.528:1.500))
    shape = dbCreateRect(cv list("M1" "drawing") list(1.488:2.180 1.528:2.240))
    shape = dbCreateRect(cv list("CA" "drawing") list(1.493:1.520 1.523:1.580))
    shape = dbCreateRect(cv list("CA" "drawing") list(1.493:2.100 1.523:2.160))
    shape = dbCreateRect(cv list("CB" "drawing") list(1.436:1.360 1.476:1.400))
    shape = dbCreateRect(cv list("CB" "drawing") list(1.436:2.280 1.476:2.320))
    shape = dbCreateRect(cv list("PC" "drawing") list(1.342:1.380 1.362:1.840))
    shape = dbCreateRect(cv list("RX" "drawing") list(1.250:1.500 1.454:1.700))
    shape = dbCreateRect(cv list("NPLUS" "drawing") list(1.150:1.280 1.554:1.840))
    shape = dbCreateRect(cv list("NW" "drawing") list(1.150:1.280 1.554:1.840))
    shape = dbCreateRect(cv list("LVTN" "drawing") list(1.150:1.280 1.554:1.840))
    shape = dbCreateRect(cv list("CT" "drawing") list(1.300:1.808 1.404:1.872))
    shape = dbCreateRect(cv list("PC" "drawing") list(1.342:1.840 1.362:2.300))
    shape = dbCreateRect(cv list("RX" "drawing") list(1.250:1.980 1.454:2.180))
    shape = dbCreateRect(cv list("PPLUS" "drawing") list(1.150:1.840 1.554:2.400))
    shape = dbCreateRect(cv list("NW" "drawing") list(1.150:1.840 1.554:2.400))
    shape = dbCreateRect(cv list("RVTP" "drawing") list(1.150:1.840 1.554:2.400))
    shape = dbCreateRect(cv list("CT" "drawing") list(1.300:1.808 1.404:1.872))
    shape = dbCreateRect(cv list("CB" "drawing") list(1.332:1.740 1.372:1.780))
    shape = dbCreateRect(cv list("CB" "drawing") list(1.332:1.900 1.372:1.940))
    shape = dbCreateRect(cv list("M1" "drawing") list(1.280:1.320 1.528:1.440))
    shape = dbCreateRect(cv list("M1" "drawing") list(1.280:2.240 1.528:2.360))
    shape = dbCreateRect(cv list("PC" "drawing") list(1.446:1.298 1.466:1.840))
    shape = dbCreateRect(cv list("RX" "drawing") list(1.354:1.500 1.558:1.700))
    shape = dbCreateRect(cv list("NPLUS" "drawing") list(1.254:1.198 1.658:1.840))
    shape = dbCreateRect(cv list("NW" "drawing") list(1.254:1.198 1.658:1.840))
    shape = dbCreateRect(cv list("LVTN" "drawing") list(1.254:1.198 1.658:1.840))
    shape = dbCreateRect(cv list("CT" "drawing") list(1.404:1.808 1.508:1.872))
    shape = dbCreateRect(cv list("PC" "drawing") list(1.342:1.298 1.362:1.840))
    shape = dbCreateRect(cv list("RX" "drawing") list(1.250:1.500 1.454:1.700))
    shape = dbCreateRect(cv list("NPLUS" "drawing") list(1.150:1.198 1.554:1.840))
    shape = dbCreateRect(cv list("NW" "drawing") list(1.150:1.198 1.554:1.840))
    shape = dbCreateRect(cv list("LVTN" "drawing") list(1.150:1.198 1.554:1.840))
    shape = dbCreateRect(cv list("CT" "drawing") list(1.300:1.348 1.404:1.412))
    shape = dbCreateRect(cv list("PC" "drawing") list(1.446:1.840 1.466:2.382))
    shape = dbCreateRect(cv list("RX" "drawing") list(1.354:1.980 1.558:2.180))
    shape = dbCreateRect(cv list("PPLUS" "drawing") list(1.254:1.840 1.658:2.482))
    shape = dbCreateRect(cv list("NW" "drawing") list(1.254:1.840 1.658:2.482))
    shape = dbCreateRect(cv list("RVTP" "drawing") list(1.254:1.840 1.658:2.482))
    shape = dbCreateRect(cv list("CT" "drawing") list(1.404:1.808 1.508:1.872))
    shape = dbCreateRect(cv list("PC" "drawing") list(1.342:1.840 1.362:2.382))
    shape = dbCreateRect(cv list("RX" "drawing") list(1.250:1.980 1.454:2.180))
    shape = dbCreateRect(cv list("PPLUS" "drawing") list(1.150:1.840 1.554:2.482))
    shape = dbCreateRect(cv list("NW" "drawing") list(1.150:1.840 1.554:2.482))
    shape = dbCreateRect(cv list("RVTP" "drawing") list(1.150:1.840 1.554:2.482))
    shape = dbCreateRect(cv list("CT" "drawing") list(1.300:2.268 1.404:2.332))
    shape = dbCreatePolygon(cv list("M1" "drawing") list(1.280:2.160 1.280:2.020 1.124:2.020 1.124:1.660 1.280:1.660 1.280:1.520 1.320:1.520 1.320:1.700 1.164:1.700 1.164:1.980 1.320:1.980 1.320:2.160))
    shape = dbCreatePolygon(cv list("M1" "drawing") list(1.404:1.980 1.436:1.980 1.436:1.700 1.404:1.700 1.404:1.660 1.476:1.660 1.476:2.020 1.404:2.020))
    shape = dbCreateRect(cv list("M1" "drawing") list(1.342:1.900 1.362:1.940))
    shape = dbCreateRect(cv list("M1" "drawing") list(1.342:1.740 1.362:1.780))
    shape = dbCreateRect(cv list("M1" "drawing") list(1.488:2.080 1.528:2.180))
    shape = dbCreateRect(cv list("M1" "drawing") list(1.488:1.500 1.528:1.600))
    shape = dbCreateRect(cv list("M1" "drawing") list(1.280:2.080 1.320:2.180))
    shape = dbCreateRect(cv list("M1" "drawing") list(1.280:1.500 1.320:1.600))
    shape = dbCreateRect(cv list("M1" "drawing") list(1.384:1.980 1.424:2.080))
    shape = dbCreateRect(cv list("M1" "drawing") list(1.384:1.600 1.424:1.700))
    shape = dbCreateRect(cv list("CB" "drawing") list(1.228:1.360 1.268:1.400))
    shape = dbCreateRect(cv list("CB" "drawing") list(1.228:2.280 1.268:2.320))
    shape = dbCreateRect(cv list("M1" "drawing") list(1.176:1.320 1.320:1.440))
    shape = dbCreateRect(cv list("M1" "drawing") list(1.176:2.240 1.320:2.360))
    shape = dbCreateRect(cv list("PC" "drawing") list(1.238:1.298 1.258:1.840))
    shape = dbCreateRect(cv list("RX" "drawing") list(1.146:1.500 1.350:1.700))
    shape = dbCreateRect(cv list("NPLUS" "drawing") list(1.046:1.198 1.450:1.840))
    shape = dbCreateRect(cv list("NW" "drawing") list(1.046:1.198 1.450:1.840))
    shape = dbCreateRect(cv list("LVTN" "drawing") list(1.046:1.198 1.450:1.840))
    shape = dbCreateRect(cv list("CT" "drawing") list(1.196:1.808 1.300:1.872))
    shape = dbCreateRect(cv list("PC" "drawing") list(1.238:1.840 1.258:2.382))
    shape = dbCreateRect(cv list("RX" "drawing") list(1.146:1.980 1.350:2.180))
    shape = dbCreateRect(cv list("PPLUS" "drawing") list(1.046:1.840 1.450:2.482))
    shape = dbCreateRect(cv list("NW" "drawing") list(1.046:1.840 1.450:2.482))
    shape = dbCreateRect(cv list("RVTP" "drawing") list(1.046:1.840 1.450:2.482))
    shape = dbCreateRect(cv list("CT" "drawing") list(1.196:1.808 1.300:1.872))
    shape = dbCreateRect(cv list("CA" "drawing") list(0.973:1.620 1.003:1.680))
    shape = dbCreateRect(cv list("CA" "drawing") list(0.973:2.000 1.003:2.060))
    shape = dbCreateRect(cv list("M1" "drawing") list(1.176:1.440 1.216:1.500))
    shape = dbCreateRect(cv list("CA" "drawing") list(1.181:1.520 1.211:1.580))
    shape = dbCreateRect(cv list("M1" "drawing") list(1.176:2.180 1.216:2.240))
    shape = dbCreateRect(cv list("CA" "drawing") list(1.181:2.100 1.211:2.160))
    shape = dbCreateRect(cv list("PC" "drawing") list(1.030:1.380 1.050:1.840))
    shape = dbCreateRect(cv list("RX" "drawing") list(0.938:1.500 1.142:1.700))
    shape = dbCreateRect(cv list("NPLUS" "drawing") list(0.838:1.280 1.242:1.840))
    shape = dbCreateRect(cv list("NW" "drawing") list(0.838:1.280 1.242:1.840))
    shape = dbCreateRect(cv list("LVTN" "drawing") list(0.838:1.280 1.242:1.840))
    shape = dbCreateRect(cv list("CT" "drawing") list(0.988:1.808 1.092:1.872))
    shape = dbCreateRect(cv list("PC" "drawing") list(1.030:1.840 1.050:2.300))
    shape = dbCreateRect(cv list("RX" "drawing") list(0.938:1.980 1.142:2.180))
    shape = dbCreateRect(cv list("PPLUS" "drawing") list(0.838:1.840 1.242:2.400))
    shape = dbCreateRect(cv list("NW" "drawing") list(0.838:1.840 1.242:2.400))
    shape = dbCreateRect(cv list("RVTP" "drawing") list(0.838:1.840 1.242:2.400))
    shape = dbCreateRect(cv list("CT" "drawing") list(0.988:1.808 1.092:1.872))
    shape = dbCreateRect(cv list("CB" "drawing") list(1.020:1.740 1.060:1.780))
    shape = dbCreateRect(cv list("CB" "drawing") list(1.020:1.900 1.060:1.940))
    shape = dbCreateRect(cv list("CB" "drawing") list(1.124:1.820 1.164:1.860))
    shape = dbCreateRect(cv list("M1" "drawing") list(0.968:1.320 1.216:1.440))
    shape = dbCreateRect(cv list("M1" "drawing") list(0.968:2.240 1.216:2.360))
    shape = dbCreateRect(cv list("PC" "drawing") list(1.030:1.298 1.050:1.840))
    shape = dbCreateRect(cv list("PC" "drawing") list(1.134:1.298 1.154:1.840))
    shape = dbCreateRect(cv list("RX" "drawing") list(0.938:1.500 1.246:1.700))
    shape = dbCreateRect(cv list("NPLUS" "drawing") list(0.838:1.198 1.346:1.840))
    shape = dbCreateRect(cv list("NW" "drawing") list(0.838:1.198 1.346:1.840))
    shape = dbCreateRect(cv list("LVTN" "drawing") list(0.838:1.198 1.346:1.840))
    shape = dbCreateRect(cv list("CT" "drawing") list(0.988:1.348 1.196:1.412))
    shape = dbCreateRect(cv list("PC" "drawing") list(1.030:1.840 1.050:2.382))
    shape = dbCreateRect(cv list("PC" "drawing") list(1.134:1.840 1.154:2.382))
    shape = dbCreateRect(cv list("RX" "drawing") list(0.938:1.980 1.246:2.180))
    shape = dbCreateRect(cv list("PPLUS" "drawing") list(0.838:1.840 1.346:2.482))
    shape = dbCreateRect(cv list("NW" "drawing") list(0.838:1.840 1.346:2.482))
    shape = dbCreateRect(cv list("RVTP" "drawing") list(0.838:1.840 1.346:2.482))
    shape = dbCreateRect(cv list("CT" "drawing") list(0.988:2.268 1.196:2.332))
    shape = dbCreatePolygon(cv list("M1" "drawing") list(0.988:2.020 0.812:2.020 0.812:1.660 0.988:1.660 0.988:1.700 0.852:1.700 0.852:1.980 0.988:1.980))
    shape = dbCreateRect(cv list("M1" "drawing") list(1.134:1.820 1.154:1.860))
    shape = dbCreateRect(cv list("M1" "drawing") list(1.030:1.900 1.050:1.940))
    shape = dbCreateRect(cv list("M1" "drawing") list(1.030:1.740 1.050:1.780))
    shape = dbCreateRect(cv list("M1" "drawing") list(1.176:2.080 1.216:2.180))
    shape = dbCreateRect(cv list("M1" "drawing") list(1.176:1.500 1.216:1.600))
    shape = dbCreateRect(cv list("M1" "drawing") list(0.968:1.980 1.008:2.080))
    shape = dbCreateRect(cv list("M1" "drawing") list(0.968:1.600 1.008:1.700))
    shape = dbCreateRect(cv list("CB" "drawing") list(0.916:1.360 0.956:1.400))
    shape = dbCreateRect(cv list("CB" "drawing") list(0.916:2.280 0.956:2.320))
    shape = dbCreateRect(cv list("M1" "drawing") list(0.864:1.320 1.008:1.440))
    shape = dbCreateRect(cv list("M1" "drawing") list(0.864:2.240 1.008:2.360))
    shape = dbCreateRect(cv list("PC" "drawing") list(0.926:1.298 0.946:1.840))
    shape = dbCreateRect(cv list("RX" "drawing") list(0.834:1.500 1.038:1.700))
    shape = dbCreateRect(cv list("NPLUS" "drawing") list(0.734:1.198 1.138:1.840))
    shape = dbCreateRect(cv list("NW" "drawing") list(0.734:1.198 1.138:1.840))
    shape = dbCreateRect(cv list("LVTN" "drawing") list(0.734:1.198 1.138:1.840))
    shape = dbCreateRect(cv list("CT" "drawing") list(0.884:1.808 0.988:1.872))
    shape = dbCreateRect(cv list("PC" "drawing") list(0.926:1.840 0.946:2.382))
    shape = dbCreateRect(cv list("RX" "drawing") list(0.834:1.980 1.038:2.180))
    shape = dbCreateRect(cv list("PPLUS" "drawing") list(0.734:1.840 1.138:2.482))
    shape = dbCreateRect(cv list("NW" "drawing") list(0.734:1.840 1.138:2.482))
    shape = dbCreateRect(cv list("RVTP" "drawing") list(0.734:1.840 1.138:2.482))
    shape = dbCreateRect(cv list("CT" "drawing") list(0.884:1.808 0.988:1.872))
    shape = dbCreateRect(cv list("CA" "drawing") list(0.869:1.520 0.899:1.580))
    shape = dbCreateRect(cv list("CA" "drawing") list(0.869:2.100 0.899:2.160))
    shape = dbCreateRect(cv list("M1" "drawing") list(0.760:1.440 0.800:1.500))
    shape = dbCreateRect(cv list("CA" "drawing") list(0.765:1.520 0.795:1.580))
    shape = dbCreateRect(cv list("M1" "drawing") list(0.760:2.180 0.800:2.240))
    shape = dbCreateRect(cv list("CA" "drawing") list(0.765:2.100 0.795:2.160))
    shape = dbCreateRect(cv list("CB" "drawing") list(0.812:1.820 0.852:1.860))
    shape = dbCreateRect(cv list("M1" "drawing") list(0.760:1.320 0.904:1.440))
    shape = dbCreateRect(cv list("M1" "drawing") list(0.760:2.240 0.904:2.360))
    shape = dbCreateRect(cv list("PC" "drawing") list(0.822:1.298 0.842:1.840))
    shape = dbCreateRect(cv list("RX" "drawing") list(0.730:1.500 0.934:1.700))
    shape = dbCreateRect(cv list("NPLUS" "drawing") list(0.630:1.198 1.034:1.840))
    shape = dbCreateRect(cv list("NW" "drawing") list(0.630:1.198 1.034:1.840))
    shape = dbCreateRect(cv list("LVTN" "drawing") list(0.630:1.198 1.034:1.840))
    shape = dbCreateRect(cv list("CT" "drawing") list(0.780:1.348 0.884:1.412))
    shape = dbCreateRect(cv list("PC" "drawing") list(0.822:1.840 0.842:2.382))
    shape = dbCreateRect(cv list("RX" "drawing") list(0.730:1.980 0.934:2.180))
    shape = dbCreateRect(cv list("PPLUS" "drawing") list(0.630:1.840 1.034:2.482))
    shape = dbCreateRect(cv list("NW" "drawing") list(0.630:1.840 1.034:2.482))
    shape = dbCreateRect(cv list("RVTP" "drawing") list(0.630:1.840 1.034:2.482))
    shape = dbCreateRect(cv list("CT" "drawing") list(0.780:2.268 0.884:2.332))
    shape = dbCreateRect(cv list("M1" "drawing") list(0.822:1.820 0.842:1.860))
    shape = dbCreateRect(cv list("M1" "drawing") list(0.760:2.080 0.800:2.180))
    shape = dbCreateRect(cv list("M1" "drawing") list(0.760:1.500 0.800:1.600))
    shape = dbCreateRect(cv list("M1" "drawing") list(0.864:2.080 0.904:2.180))
    shape = dbCreateRect(cv list("M1" "drawing") list(0.864:1.500 0.904:1.600))
    shape = dbCreateRect(cv list("CA" "drawing") list(0.661:1.620 0.691:1.680))
    shape = dbCreateRect(cv list("CA" "drawing") list(0.661:2.000 0.691:2.060))
    shape = dbCreateRect(cv list("CA" "drawing") list(0.557:1.520 0.587:1.580))
    shape = dbCreateRect(cv list("CA" "drawing") list(0.453:1.520 0.483:1.580))
    shape = dbCreateRect(cv list("M1" "drawing") list(0.448:2.180 0.488:2.240))
    shape = dbCreateRect(cv list("CA" "drawing") list(0.453:2.100 0.483:2.160))
    shape = dbCreateRect(cv list("M1" "drawing") list(0.344:1.440 0.384:1.500))
    shape = dbCreateRect(cv list("CA" "drawing") list(0.349:1.520 0.379:1.580))
    shape = dbCreateRect(cv list("M1" "drawing") list(0.760:1.440 0.800:1.500))
    shape = dbCreateRect(cv list("M1" "drawing") list(0.760:2.180 0.800:2.240))
    shape = dbCreateRect(cv list("CA" "drawing") list(0.765:1.520 0.795:1.580))
    shape = dbCreateRect(cv list("CA" "drawing") list(0.765:2.100 0.795:2.160))
    shape = dbCreateRect(cv list("CB" "drawing") list(0.708:1.360 0.748:1.400))
    shape = dbCreateRect(cv list("CB" "drawing") list(0.708:2.280 0.748:2.320))
    shape = dbCreateRect(cv list("CB" "drawing") list(0.604:1.740 0.644:1.780))
    shape = dbCreateRect(cv list("CB" "drawing") list(0.500:1.820 0.540:1.860))
    shape = dbCreateRect(cv list("CB" "drawing") list(0.396:1.900 0.436:1.940))
    shape = dbCreateRect(cv list("M1" "drawing") list(0.344:1.320 0.800:1.440))
    shape = dbCreateRect(cv list("M1" "drawing") list(0.344:2.240 0.800:2.360))
    shape = dbCreateRect(cv list("PC" "drawing") list(0.718:1.298 0.738:1.840))
    shape = dbCreateRect(cv list("RX" "drawing") list(0.626:1.500 0.830:1.700))
    shape = dbCreateRect(cv list("NPLUS" "drawing") list(0.526:1.198 0.930:1.840))
    shape = dbCreateRect(cv list("NW" "drawing") list(0.526:1.198 0.930:1.840))
    shape = dbCreateRect(cv list("LVTN" "drawing") list(0.526:1.198 0.930:1.840))
    shape = dbCreateRect(cv list("CT" "drawing") list(0.676:1.808 0.780:1.872))
    shape = dbCreateRect(cv list("PC" "drawing") list(0.614:1.298 0.634:1.840))
    shape = dbCreateRect(cv list("PC" "drawing") list(0.510:1.298 0.530:1.840))
    shape = dbCreateRect(cv list("PC" "drawing") list(0.406:1.298 0.426:1.840))
    shape = dbCreateRect(cv list("RX" "drawing") list(0.314:1.500 0.726:1.700))
    shape = dbCreateRect(cv list("NPLUS" "drawing") list(0.214:1.198 0.826:1.840))
    shape = dbCreateRect(cv list("NW" "drawing") list(0.214:1.198 0.826:1.840))
    shape = dbCreateRect(cv list("LVTN" "drawing") list(0.214:1.198 0.826:1.840))
    shape = dbCreateRect(cv list("CT" "drawing") list(0.364:1.348 0.676:1.412))
    shape = dbCreateRect(cv list("PC" "drawing") list(0.718:1.840 0.738:2.382))
    shape = dbCreateRect(cv list("RX" "drawing") list(0.626:1.980 0.830:2.180))
    shape = dbCreateRect(cv list("PPLUS" "drawing") list(0.526:1.840 0.930:2.482))
    shape = dbCreateRect(cv list("NW" "drawing") list(0.526:1.840 0.930:2.482))
    shape = dbCreateRect(cv list("RVTP" "drawing") list(0.526:1.840 0.930:2.482))
    shape = dbCreateRect(cv list("CT" "drawing") list(0.676:1.808 0.780:1.872))
    shape = dbCreateRect(cv list("PC" "drawing") list(0.614:1.840 0.634:2.382))
    shape = dbCreateRect(cv list("PC" "drawing") list(0.510:1.840 0.530:2.382))
    shape = dbCreateRect(cv list("PC" "drawing") list(0.406:1.840 0.426:2.382))
    shape = dbCreateRect(cv list("RX" "drawing") list(0.314:1.980 0.726:2.180))
    shape = dbCreateRect(cv list("PPLUS" "drawing") list(0.214:1.840 0.826:2.482))
    shape = dbCreateRect(cv list("NW" "drawing") list(0.214:1.840 0.826:2.482))
    shape = dbCreateRect(cv list("RVTP" "drawing") list(0.214:1.840 0.826:2.482))
    shape = dbCreateRect(cv list("CT" "drawing") list(0.364:2.268 0.676:2.332))
    shape = dbCreatePolygon(cv list("M1" "drawing") list(0.676:1.980 0.812:1.980 0.812:1.700 0.676:1.700 0.676:1.660 0.852:1.660 0.852:2.020 0.676:2.020))
    shape = dbCreateRect(cv list("M1" "drawing") list(0.468:1.530 0.572:1.570))
    shape = dbCreateRect(cv list("M1" "drawing") list(0.406:1.900 0.426:1.940))
    shape = dbCreateRect(cv list("M1" "drawing") list(0.510:1.820 0.530:1.860))
    shape = dbCreateRect(cv list("M1" "drawing") list(0.614:1.740 0.634:1.780))
    shape = dbCreateRect(cv list("M1" "drawing") list(0.760:2.080 0.800:2.180))
    shape = dbCreateRect(cv list("M1" "drawing") list(0.760:1.500 0.800:1.600))
    shape = dbCreateRect(cv list("M1" "drawing") list(0.344:1.500 0.384:1.600))
    shape = dbCreateRect(cv list("M1" "drawing") list(0.448:2.080 0.488:2.180))
    shape = dbCreateRect(cv list("M1" "drawing") list(0.448:1.500 0.488:1.600))
    shape = dbCreateRect(cv list("M1" "drawing") list(0.552:1.500 0.592:1.600))
    shape = dbCreateRect(cv list("M1" "drawing") list(0.656:1.980 0.696:2.080))
    shape = dbCreateRect(cv list("M1" "drawing") list(0.656:1.600 0.696:1.700))
    shape = dbCreateRect(cv list("CA" "drawing") list(0.245:1.620 0.275:1.680))
    shape = dbCreateRect(cv list("CA" "drawing") list(0.245:2.000 0.275:2.060))
    shape = dbCreateRect(cv list("M1" "drawing") list(0.136:1.440 0.176:1.500))
    shape = dbCreateRect(cv list("CA" "drawing") list(0.141:1.520 0.171:1.580))
    shape = dbCreateRect(cv list("M1" "drawing") list(0.136:2.180 0.176:2.240))
    shape = dbCreateRect(cv list("CA" "drawing") list(0.141:2.100 0.171:2.160))
    shape = dbCreateRect(cv list("M1" "drawing") list(0.344:1.440 0.384:1.500))
    shape = dbCreateRect(cv list("M1" "drawing") list(0.344:2.180 0.384:2.240))
    shape = dbCreateRect(cv list("CA" "drawing") list(0.349:1.520 0.379:1.580))
    shape = dbCreateRect(cv list("CA" "drawing") list(0.349:2.100 0.379:2.160))
    shape = dbCreateRect(cv list("CB" "drawing") list(0.292:1.360 0.332:1.400))
    shape = dbCreateRect(cv list("CB" "drawing") list(0.292:2.280 0.332:2.320))
    shape = dbCreateRect(cv list("CB" "drawing") list(0.188:1.820 0.228:1.860))
    shape = dbCreateRect(cv list("M1" "drawing") list(0.136:1.320 0.384:1.440))
    shape = dbCreateRect(cv list("M1" "drawing") list(0.136:2.240 0.384:2.360))
    shape = dbCreateRect(cv list("PC" "drawing") list(0.302:1.298 0.322:1.840))
    shape = dbCreateRect(cv list("RX" "drawing") list(0.210:1.500 0.414:1.700))
    shape = dbCreateRect(cv list("NPLUS" "drawing") list(0.110:1.198 0.514:1.840))
    shape = dbCreateRect(cv list("NW" "drawing") list(0.110:1.198 0.514:1.840))
    shape = dbCreateRect(cv list("LVTN" "drawing") list(0.110:1.198 0.514:1.840))
    shape = dbCreateRect(cv list("CT" "drawing") list(0.260:1.808 0.364:1.872))
    shape = dbCreateRect(cv list("PC" "drawing") list(0.198:1.298 0.218:1.840))
    shape = dbCreateRect(cv list("RX" "drawing") list(0.106:1.500 0.310:1.700))
    shape = dbCreateRect(cv list("NPLUS" "drawing") list(0.006:1.198 0.410:1.840))
    shape = dbCreateRect(cv list("NW" "drawing") list(0.006:1.198 0.410:1.840))
    shape = dbCreateRect(cv list("LVTN" "drawing") list(0.006:1.198 0.410:1.840))
    shape = dbCreateRect(cv list("CT" "drawing") list(0.156:1.348 0.260:1.412))
    shape = dbCreateRect(cv list("PC" "drawing") list(0.302:1.840 0.322:2.382))
    shape = dbCreateRect(cv list("RX" "drawing") list(0.210:1.980 0.414:2.180))
    shape = dbCreateRect(cv list("PPLUS" "drawing") list(0.110:1.840 0.514:2.482))
    shape = dbCreateRect(cv list("NW" "drawing") list(0.110:1.840 0.514:2.482))
    shape = dbCreateRect(cv list("RVTP" "drawing") list(0.110:1.840 0.514:2.482))
    shape = dbCreateRect(cv list("CT" "drawing") list(0.260:1.808 0.364:1.872))
    shape = dbCreateRect(cv list("PC" "drawing") list(0.198:1.840 0.218:2.382))
    shape = dbCreateRect(cv list("RX" "drawing") list(0.106:1.980 0.310:2.180))
    shape = dbCreateRect(cv list("PPLUS" "drawing") list(0.006:1.840 0.410:2.482))
    shape = dbCreateRect(cv list("NW" "drawing") list(0.006:1.840 0.410:2.482))
    shape = dbCreateRect(cv list("RVTP" "drawing") list(0.006:1.840 0.410:2.482))
    shape = dbCreateRect(cv list("CT" "drawing") list(0.156:2.268 0.260:2.332))
    shape = dbCreatePolygon(cv list("M1" "drawing") list(0.260:1.980 0.292:1.980 0.292:1.700 0.260:1.700 0.260:1.660 0.332:1.660 0.332:2.020 0.260:2.020))
    shape = dbCreateRect(cv list("M1" "drawing") list(0.198:1.820 0.218:1.860))
    shape = dbCreateRect(cv list("M1" "drawing") list(0.344:2.080 0.384:2.180))
    shape = dbCreateRect(cv list("M1" "drawing") list(0.344:1.500 0.384:1.600))
    shape = dbCreateRect(cv list("M1" "drawing") list(0.136:2.080 0.176:2.180))
    shape = dbCreateRect(cv list("M1" "drawing") list(0.136:1.500 0.176:1.600))
    shape = dbCreateRect(cv list("M1" "drawing") list(0.240:1.980 0.280:2.080))
    shape = dbCreateRect(cv list("M1" "drawing") list(0.240:1.600 0.280:1.700))
    shape = dbCreateRect(cv list("CA" "drawing") list(0.037:1.620 0.067:1.680))
    shape = dbCreateRect(cv list("CA" "drawing") list(0.037:2.000 0.067:2.060))
    shape = dbCreateRect(cv list("M1" "drawing") list(-0.072:1.440 -0.032:1.500))
    shape = dbCreateRect(cv list("CA" "drawing") list(-0.067:1.520 -0.037:1.580))
    shape = dbCreateRect(cv list("M1" "drawing") list(-0.072:2.180 -0.032:2.240))
    shape = dbCreateRect(cv list("CA" "drawing") list(-0.067:2.100 -0.037:2.160))
    shape = dbCreateRect(cv list("M1" "drawing") list(0.136:1.440 0.176:1.500))
    shape = dbCreateRect(cv list("M1" "drawing") list(0.136:2.180 0.176:2.240))
    shape = dbCreateRect(cv list("CA" "drawing") list(0.141:1.520 0.171:1.580))
    shape = dbCreateRect(cv list("CA" "drawing") list(0.141:2.100 0.171:2.160))
    shape = dbCreateRect(cv list("CB" "drawing") list(0.084:1.360 0.124:1.400))
    shape = dbCreateRect(cv list("CB" "drawing") list(0.084:2.280 0.124:2.320))
    shape = dbCreateRect(cv list("CB" "drawing") list(-0.020:1.740 0.020:1.780))
    shape = dbCreateRect(cv list("M1" "drawing") list(-0.072:1.320 0.176:1.440))
    shape = dbCreateRect(cv list("M1" "drawing") list(-0.072:2.240 0.176:2.360))
    shape = dbCreateRect(cv list("PC" "drawing") list(0.094:1.298 0.114:1.840))
    shape = dbCreateRect(cv list("RX" "drawing") list(0.002:1.500 0.206:1.700))
    shape = dbCreateRect(cv list("NPLUS" "drawing") list(-0.098:1.198 0.306:1.840))
    shape = dbCreateRect(cv list("NW" "drawing") list(-0.098:1.198 0.306:1.840))
    shape = dbCreateRect(cv list("LVTN" "drawing") list(-0.098:1.198 0.306:1.840))
    shape = dbCreateRect(cv list("CT" "drawing") list(0.052:1.808 0.156:1.872))
    shape = dbCreateRect(cv list("PC" "drawing") list(-0.010:1.298 0.010:1.840))
    shape = dbCreateRect(cv list("RX" "drawing") list(-0.102:1.500 0.102:1.700))
    shape = dbCreateRect(cv list("NPLUS" "drawing") list(-0.202:1.198 0.202:1.840))
    shape = dbCreateRect(cv list("NW" "drawing") list(-0.202:1.198 0.202:1.840))
    shape = dbCreateRect(cv list("LVTN" "drawing") list(-0.202:1.198 0.202:1.840))
    shape = dbCreateRect(cv list("CT" "drawing") list(-0.052:1.348 0.052:1.412))
    shape = dbCreateRect(cv list("PC" "drawing") list(0.094:1.840 0.114:2.382))
    shape = dbCreateRect(cv list("RX" "drawing") list(0.002:1.980 0.206:2.180))
    shape = dbCreateRect(cv list("PPLUS" "drawing") list(-0.098:1.840 0.306:2.482))
    shape = dbCreateRect(cv list("NW" "drawing") list(-0.098:1.840 0.306:2.482))
    shape = dbCreateRect(cv list("RVTP" "drawing") list(-0.098:1.840 0.306:2.482))
    shape = dbCreateRect(cv list("CT" "drawing") list(0.052:1.808 0.156:1.872))
    shape = dbCreateRect(cv list("PC" "drawing") list(-0.010:1.840 0.010:2.382))
    shape = dbCreateRect(cv list("RX" "drawing") list(-0.102:1.980 0.102:2.180))
    shape = dbCreateRect(cv list("PPLUS" "drawing") list(-0.202:1.840 0.202:2.482))
    shape = dbCreateRect(cv list("NW" "drawing") list(-0.202:1.840 0.202:2.482))
    shape = dbCreateRect(cv list("RVTP" "drawing") list(-0.202:1.840 0.202:2.482))
    shape = dbCreateRect(cv list("CT" "drawing") list(-0.052:2.268 0.052:2.332))
    shape = dbCreatePolygon(cv list("M1" "drawing") list(0.052:1.980 0.084:1.980 0.084:1.700 0.052:1.700 0.052:1.660 0.124:1.660 0.124:2.020 0.052:2.020))
    shape = dbCreateRect(cv list("M1" "drawing") list(-0.010:1.740 0.010:1.780))
    shape = dbCreateRect(cv list("M1" "drawing") list(0.136:2.080 0.176:2.180))
    shape = dbCreateRect(cv list("M1" "drawing") list(0.136:1.500 0.176:1.600))
    shape = dbCreateRect(cv list("M1" "drawing") list(-0.072:2.080 -0.032:2.180))
    shape = dbCreateRect(cv list("M1" "drawing") list(-0.072:1.500 -0.032:1.600))
    shape = dbCreateRect(cv list("M1" "drawing") list(0.032:1.980 0.072:2.080))
    shape = dbCreateRect(cv list("M1" "drawing") list(0.032:1.600 0.072:1.700))
    shape = dbCreateRect(cv list("M2" "drawing") list(-0.228:1.740 -0.188:1.780))
    shape = dbCreateRect(cv list("M1" "drawing") list(-0.228:1.740 -0.188:1.780))
    shape = dbCreateRect(cv list("M2" "drawing") list(-0.852:1.820 -0.812:1.860))
    shape = dbCreateRect(cv list("M1" "drawing") list(-0.852:1.820 -0.812:1.860))
    shape = dbCreateRect(cv list("V1" "drawing") list(-0.872:1.820 -0.792:1.860))
    shape = dbCreateRect(cv list("V1" "drawing") list(-0.248:1.740 -0.168:1.780))
    shape = dbCreatePolygon(cv list("M2" "drawing") list(-0.852:1.840 -0.852:1.660 -0.188:1.660 -0.188:1.760 -0.228:1.760 -0.228:1.700 -0.812:1.700 -0.812:1.840))
    shape = dbCreatePolygon(cv list("M1" "drawing") list(-0.292:1.840 -0.292:1.900 -0.104:1.900 -0.104:1.940 -0.332:1.940 -0.332:1.840))
    shape = dbCreatePolygon(cv list("M1" "drawing") list(-1.332:1.840 -1.332:1.900 -1.144:1.900 -1.144:1.940 -1.372:1.940 -1.372:1.840))
    shape = dbCreateRect(cv list("M1" "drawing") list(-0.072:1.440 -0.032:1.500))
    shape = dbCreateRect(cv list("CA" "drawing") list(-0.067:1.520 -0.037:1.580))
    shape = dbCreateRect(cv list("M1" "drawing") list(-0.072:2.180 -0.032:2.240))
    shape = dbCreateRect(cv list("CA" "drawing") list(-0.067:2.100 -0.037:2.160))
    shape = dbCreateRect(cv list("CA" "drawing") list(-0.171:2.000 -0.141:2.060))
    shape = dbCreateRect(cv list("CA" "drawing") list(-0.275:1.620 -0.245:1.680))
    shape = dbCreateRect(cv list("M1" "drawing") list(-0.280:2.180 -0.240:2.240))
    shape = dbCreateRect(cv list("CA" "drawing") list(-0.275:2.100 -0.245:2.160))
    shape = dbCreateRect(cv list("CB" "drawing") list(-0.124:1.900 -0.084:1.940))
    shape = dbCreateRect(cv list("CB" "drawing") list(-0.228:1.740 -0.188:1.780))
    shape = dbCreateRect(cv list("M1" "drawing") list(-0.280:1.320 -0.032:1.440))
    shape = dbCreateRect(cv list("M1" "drawing") list(-0.280:2.240 -0.032:2.360))
    shape = dbCreateRect(cv list("PC" "drawing") list(-0.114:1.298 -0.094:1.840))
    shape = dbCreateRect(cv list("PC" "drawing") list(-0.218:1.298 -0.198:1.840))
    shape = dbCreateRect(cv list("RX" "drawing") list(-0.310:1.500 -0.002:1.700))
    shape = dbCreateRect(cv list("NPLUS" "drawing") list(-0.410:1.198 0.098:1.840))
    shape = dbCreateRect(cv list("NW" "drawing") list(-0.410:1.198 0.098:1.840))
    shape = dbCreateRect(cv list("LVTN" "drawing") list(-0.410:1.198 0.098:1.840))
    shape = dbCreateRect(cv list("CT" "drawing") list(-0.260:1.348 -0.052:1.412))
    shape = dbCreateRect(cv list("PC" "drawing") list(-0.114:1.840 -0.094:2.382))
    shape = dbCreateRect(cv list("PC" "drawing") list(-0.218:1.840 -0.198:2.382))
    shape = dbCreateRect(cv list("RX" "drawing") list(-0.310:1.980 -0.002:2.180))
    shape = dbCreateRect(cv list("PPLUS" "drawing") list(-0.410:1.840 0.098:2.482))
    shape = dbCreateRect(cv list("NW" "drawing") list(-0.410:1.840 0.098:2.482))
    shape = dbCreateRect(cv list("RVTP" "drawing") list(-0.410:1.840 0.098:2.482))
    shape = dbCreateRect(cv list("CT" "drawing") list(-0.260:2.268 -0.052:2.332))
    shape = dbCreateRect(cv list("M1" "drawing") list(-0.252:1.900 -0.060:1.940))
    shape = dbCreateRect(cv list("M1" "drawing") list(-0.252:1.740 -0.060:1.780))
    shape = dbCreatePolygon(cv list("M1" "drawing") list(-0.260:1.660 0.020:1.660 0.020:2.020 -0.156:2.020 -0.156:1.980 -0.020:1.980 -0.020:1.700 -0.260:1.700))
    shape = dbCreateRect(cv list("M1" "drawing") list(-0.218:1.740 -0.198:1.780))
    shape = dbCreateRect(cv list("M1" "drawing") list(-0.114:1.900 -0.094:1.940))
    shape = dbCreateRect(cv list("M1" "drawing") list(-0.280:2.080 -0.240:2.180))
    shape = dbCreateRect(cv list("M1" "drawing") list(-0.280:1.600 -0.240:1.700))
    shape = dbCreateRect(cv list("M1" "drawing") list(-0.176:1.980 -0.136:2.080))
    shape = dbCreateRect(cv list("M1" "drawing") list(-0.072:2.080 -0.032:2.180))
    shape = dbCreateRect(cv list("M1" "drawing") list(-0.072:1.500 -0.032:1.600))
    shape = dbCreateRect(cv list("CB" "drawing") list(-0.332:1.360 -0.292:1.400))
    shape = dbCreateRect(cv list("CB" "drawing") list(-0.332:2.280 -0.292:2.320))
    shape = dbCreateRect(cv list("M1" "drawing") list(-0.384:1.320 -0.240:1.440))
    shape = dbCreateRect(cv list("M1" "drawing") list(-0.384:2.240 -0.240:2.360))
    shape = dbCreateRect(cv list("PC" "drawing") list(-0.322:1.298 -0.302:1.840))
    shape = dbCreateRect(cv list("RX" "drawing") list(-0.414:1.500 -0.210:1.700))
    shape = dbCreateRect(cv list("NPLUS" "drawing") list(-0.514:1.198 -0.110:1.840))
    shape = dbCreateRect(cv list("NW" "drawing") list(-0.514:1.198 -0.110:1.840))
    shape = dbCreateRect(cv list("LVTN" "drawing") list(-0.514:1.198 -0.110:1.840))
    shape = dbCreateRect(cv list("CT" "drawing") list(-0.364:1.808 -0.260:1.872))
    shape = dbCreateRect(cv list("PC" "drawing") list(-0.322:1.840 -0.302:2.382))
    shape = dbCreateRect(cv list("RX" "drawing") list(-0.414:1.980 -0.210:2.180))
    shape = dbCreateRect(cv list("PPLUS" "drawing") list(-0.514:1.840 -0.110:2.482))
    shape = dbCreateRect(cv list("NW" "drawing") list(-0.514:1.840 -0.110:2.482))
    shape = dbCreateRect(cv list("RVTP" "drawing") list(-0.514:1.840 -0.110:2.482))
    shape = dbCreateRect(cv list("CT" "drawing") list(-0.364:1.808 -0.260:1.872))
    shape = dbCreateRect(cv list("M1" "drawing") list(-0.592:1.500 -0.552:1.600))
    shape = dbCreateRect(cv list("M1" "drawing") list(-0.592:2.080 -0.552:2.180))
    shape = dbCreateRect(cv list("M1" "drawing") list(-0.696:1.600 -0.656:1.700))
    shape = dbCreateRect(cv list("M1" "drawing") list(-0.800:1.500 -0.760:1.600))
    shape = dbCreateRect(cv list("M1" "drawing") list(-0.800:1.980 -0.760:2.080))
    shape = dbCreateRect(cv list("M1" "drawing") list(-0.634:1.900 -0.614:1.940))
    shape = dbCreateRect(cv list("M1" "drawing") list(-0.738:1.740 -0.718:1.780))
    shape = dbCreatePolygon(cv list("M1" "drawing") list(-0.780:1.980 -0.540:1.980 -0.540:1.700 -0.676:1.700 -0.676:1.660 -0.500:1.660 -0.500:2.020 -0.780:2.020))
    shape = dbCreateRect(cv list("M1" "drawing") list(-0.772:1.740 -0.580:1.780))
    shape = dbCreateRect(cv list("M1" "drawing") list(-0.772:1.900 -0.580:1.940))
    shape = dbCreateRect(cv list("CT" "drawing") list(-0.780:2.268 -0.572:2.332))
    shape = dbCreateRect(cv list("RVTP" "drawing") list(-0.930:1.840 -0.422:2.482))
    shape = dbCreateRect(cv list("NW" "drawing") list(-0.930:1.840 -0.422:2.482))
    shape = dbCreateRect(cv list("PPLUS" "drawing") list(-0.930:1.840 -0.422:2.482))
    shape = dbCreateRect(cv list("RX" "drawing") list(-0.830:1.980 -0.522:2.180))
    shape = dbCreateRect(cv list("PC" "drawing") list(-0.738:1.840 -0.718:2.382))
    shape = dbCreateRect(cv list("PC" "drawing") list(-0.634:1.840 -0.614:2.382))
    shape = dbCreateRect(cv list("CT" "drawing") list(-0.780:1.348 -0.572:1.412))
    shape = dbCreateRect(cv list("LVTN" "drawing") list(-0.930:1.198 -0.422:1.840))
    shape = dbCreateRect(cv list("NW" "drawing") list(-0.930:1.198 -0.422:1.840))
    shape = dbCreateRect(cv list("NPLUS" "drawing") list(-0.930:1.198 -0.422:1.840))
    shape = dbCreateRect(cv list("RX" "drawing") list(-0.830:1.500 -0.522:1.700))
    shape = dbCreateRect(cv list("PC" "drawing") list(-0.738:1.298 -0.718:1.840))
    shape = dbCreateRect(cv list("PC" "drawing") list(-0.634:1.298 -0.614:1.840))
    shape = dbCreateRect(cv list("M1" "drawing") list(-0.800:2.240 -0.552:2.360))
    shape = dbCreateRect(cv list("M1" "drawing") list(-0.800:1.320 -0.552:1.440))
    shape = dbCreateRect(cv list("CB" "drawing") list(-0.748:1.740 -0.708:1.780))
    shape = dbCreateRect(cv list("CB" "drawing") list(-0.644:1.900 -0.604:1.940))
    shape = dbCreateRect(cv list("CA" "drawing") list(-0.795:2.000 -0.765:2.060))
    shape = dbCreateRect(cv list("CA" "drawing") list(-0.795:1.520 -0.765:1.580))
    shape = dbCreateRect(cv list("M1" "drawing") list(-0.800:1.440 -0.760:1.500))
    shape = dbCreateRect(cv list("CA" "drawing") list(-0.691:1.620 -0.661:1.680))
    shape = dbCreateRect(cv list("CA" "drawing") list(-0.587:2.100 -0.557:2.160))
    shape = dbCreateRect(cv list("M1" "drawing") list(-0.592:2.180 -0.552:2.240))
    shape = dbCreateRect(cv list("CA" "drawing") list(-0.587:1.520 -0.557:1.580))
    shape = dbCreateRect(cv list("M1" "drawing") list(-0.592:1.440 -0.552:1.500))
    shape = dbCreateRect(cv list("CT" "drawing") list(-0.572:1.808 -0.468:1.872))
    shape = dbCreateRect(cv list("RVTP" "drawing") list(-0.722:1.840 -0.318:2.482))
    shape = dbCreateRect(cv list("NW" "drawing") list(-0.722:1.840 -0.318:2.482))
    shape = dbCreateRect(cv list("PPLUS" "drawing") list(-0.722:1.840 -0.318:2.482))
    shape = dbCreateRect(cv list("RX" "drawing") list(-0.622:1.980 -0.418:2.180))
    shape = dbCreateRect(cv list("PC" "drawing") list(-0.530:1.840 -0.510:2.382))
    shape = dbCreateRect(cv list("CT" "drawing") list(-0.572:1.808 -0.468:1.872))
    shape = dbCreateRect(cv list("LVTN" "drawing") list(-0.722:1.198 -0.318:1.840))
    shape = dbCreateRect(cv list("NW" "drawing") list(-0.722:1.198 -0.318:1.840))
    shape = dbCreateRect(cv list("NPLUS" "drawing") list(-0.722:1.198 -0.318:1.840))
    shape = dbCreateRect(cv list("RX" "drawing") list(-0.622:1.500 -0.418:1.700))
    shape = dbCreateRect(cv list("PC" "drawing") list(-0.530:1.298 -0.510:1.840))
    shape = dbCreateRect(cv list("M1" "drawing") list(-0.592:2.240 -0.448:2.360))
    shape = dbCreateRect(cv list("M1" "drawing") list(-0.592:1.320 -0.448:1.440))
    shape = dbCreateRect(cv list("CB" "drawing") list(-0.540:2.280 -0.500:2.320))
    shape = dbCreateRect(cv list("CB" "drawing") list(-0.540:1.360 -0.500:1.400))
    shape = dbCreateRect(cv list("M1" "drawing") list(-0.384:1.600 -0.344:1.700))
    shape = dbCreateRect(cv list("M1" "drawing") list(-0.384:1.980 -0.344:2.080))
    shape = dbCreateRect(cv list("M1" "drawing") list(-0.488:1.500 -0.448:1.600))
    shape = dbCreateRect(cv list("M1" "drawing") list(-0.488:2.080 -0.448:2.180))
    shape = dbCreateRect(cv list("M1" "drawing") list(-0.426:1.820 -0.406:1.860))
    shape = dbCreatePolygon(cv list("M1" "drawing") list(-0.364:1.980 -0.332:1.980 -0.332:1.700 -0.364:1.700 -0.364:1.660 -0.292:1.660 -0.292:2.020 -0.364:2.020))
    shape = dbCreateRect(cv list("CT" "drawing") list(-0.468:2.268 -0.364:2.332))
    shape = dbCreateRect(cv list("RVTP" "drawing") list(-0.618:1.840 -0.214:2.482))
    shape = dbCreateRect(cv list("NW" "drawing") list(-0.618:1.840 -0.214:2.482))
    shape = dbCreateRect(cv list("PPLUS" "drawing") list(-0.618:1.840 -0.214:2.482))
    shape = dbCreateRect(cv list("RX" "drawing") list(-0.518:1.980 -0.314:2.180))
    shape = dbCreateRect(cv list("PC" "drawing") list(-0.426:1.840 -0.406:2.382))
    shape = dbCreateRect(cv list("CT" "drawing") list(-0.468:1.348 -0.364:1.412))
    shape = dbCreateRect(cv list("LVTN" "drawing") list(-0.618:1.198 -0.214:1.840))
    shape = dbCreateRect(cv list("NW" "drawing") list(-0.618:1.198 -0.214:1.840))
    shape = dbCreateRect(cv list("NPLUS" "drawing") list(-0.618:1.198 -0.214:1.840))
    shape = dbCreateRect(cv list("RX" "drawing") list(-0.518:1.500 -0.314:1.700))
    shape = dbCreateRect(cv list("PC" "drawing") list(-0.426:1.298 -0.406:1.840))
    shape = dbCreateRect(cv list("M1" "drawing") list(-0.488:2.240 -0.344:2.360))
    shape = dbCreateRect(cv list("M1" "drawing") list(-0.488:1.320 -0.344:1.440))
    shape = dbCreateRect(cv list("CB" "drawing") list(-0.436:1.820 -0.396:1.860))
    shape = dbCreateRect(cv list("CA" "drawing") list(-0.483:2.100 -0.453:2.160))
    shape = dbCreateRect(cv list("M1" "drawing") list(-0.488:2.180 -0.448:2.240))
    shape = dbCreateRect(cv list("CA" "drawing") list(-0.483:1.520 -0.453:1.580))
    shape = dbCreateRect(cv list("M1" "drawing") list(-0.488:1.440 -0.448:1.500))
    shape = dbCreateRect(cv list("CA" "drawing") list(-0.379:2.000 -0.349:2.060))
    shape = dbCreateRect(cv list("CA" "drawing") list(-0.379:1.620 -0.349:1.680))
    shape = dbCreateRect(cv list("M1" "drawing") list(-0.520:1.820 -0.372:1.860))
    shape = dbCreateRect(cv list("CB" "drawing") list(-0.852:1.360 -0.812:1.400))
    shape = dbCreateRect(cv list("CB" "drawing") list(-0.852:2.280 -0.812:2.320))
    shape = dbCreateRect(cv list("M1" "drawing") list(-0.904:1.320 -0.760:1.440))
    shape = dbCreateRect(cv list("M1" "drawing") list(-0.904:2.240 -0.760:2.360))
    shape = dbCreateRect(cv list("PC" "drawing") list(-0.842:1.298 -0.822:1.840))
    shape = dbCreateRect(cv list("RX" "drawing") list(-0.934:1.500 -0.730:1.700))
    shape = dbCreateRect(cv list("NPLUS" "drawing") list(-1.034:1.198 -0.630:1.840))
    shape = dbCreateRect(cv list("NW" "drawing") list(-1.034:1.198 -0.630:1.840))
    shape = dbCreateRect(cv list("LVTN" "drawing") list(-1.034:1.198 -0.630:1.840))
    shape = dbCreateRect(cv list("CT" "drawing") list(-0.884:1.808 -0.780:1.872))
    shape = dbCreateRect(cv list("PC" "drawing") list(-0.842:1.840 -0.822:2.382))
    shape = dbCreateRect(cv list("RX" "drawing") list(-0.934:1.980 -0.730:2.180))
    shape = dbCreateRect(cv list("PPLUS" "drawing") list(-1.034:1.840 -0.630:2.482))
    shape = dbCreateRect(cv list("NW" "drawing") list(-1.034:1.840 -0.630:2.482))
    shape = dbCreateRect(cv list("RVTP" "drawing") list(-1.034:1.840 -0.630:2.482))
    shape = dbCreateRect(cv list("CT" "drawing") list(-0.884:1.808 -0.780:1.872))
    shape = dbCreateRect(cv list("M1" "drawing") list(-1.112:1.500 -1.072:1.600))
    shape = dbCreateRect(cv list("M1" "drawing") list(-1.112:2.080 -1.072:2.180))
    shape = dbCreateRect(cv list("M1" "drawing") list(-1.216:1.980 -1.176:2.080))
    shape = dbCreateRect(cv list("M1" "drawing") list(-1.320:1.600 -1.280:1.700))
    shape = dbCreateRect(cv list("M1" "drawing") list(-1.320:2.080 -1.280:2.180))
    shape = dbCreateRect(cv list("M1" "drawing") list(-1.154:1.900 -1.134:1.940))
    shape = dbCreateRect(cv list("M1" "drawing") list(-1.258:1.740 -1.238:1.780))
    shape = dbCreatePolygon(cv list("M1" "drawing") list(-1.300:1.660 -1.020:1.660 -1.020:2.020 -1.196:2.020 -1.196:1.980 -1.060:1.980 -1.060:1.700 -1.300:1.700))
    shape = dbCreateRect(cv list("M1" "drawing") list(-1.292:1.740 -1.100:1.780))
    shape = dbCreateRect(cv list("M1" "drawing") list(-1.292:1.900 -1.100:1.940))
    shape = dbCreateRect(cv list("CT" "drawing") list(-1.300:2.268 -1.092:2.332))
    shape = dbCreateRect(cv list("RVTP" "drawing") list(-1.450:1.840 -0.942:2.482))
    shape = dbCreateRect(cv list("NW" "drawing") list(-1.450:1.840 -0.942:2.482))
    shape = dbCreateRect(cv list("PPLUS" "drawing") list(-1.450:1.840 -0.942:2.482))
    shape = dbCreateRect(cv list("RX" "drawing") list(-1.350:1.980 -1.042:2.180))
    shape = dbCreateRect(cv list("PC" "drawing") list(-1.258:1.840 -1.238:2.382))
    shape = dbCreateRect(cv list("PC" "drawing") list(-1.154:1.840 -1.134:2.382))
    shape = dbCreateRect(cv list("CT" "drawing") list(-1.300:1.348 -1.092:1.412))
    shape = dbCreateRect(cv list("LVTN" "drawing") list(-1.450:1.198 -0.942:1.840))
    shape = dbCreateRect(cv list("NW" "drawing") list(-1.450:1.198 -0.942:1.840))
    shape = dbCreateRect(cv list("NPLUS" "drawing") list(-1.450:1.198 -0.942:1.840))
    shape = dbCreateRect(cv list("RX" "drawing") list(-1.350:1.500 -1.042:1.700))
    shape = dbCreateRect(cv list("PC" "drawing") list(-1.258:1.298 -1.238:1.840))
    shape = dbCreateRect(cv list("PC" "drawing") list(-1.154:1.298 -1.134:1.840))
    shape = dbCreateRect(cv list("M1" "drawing") list(-1.320:2.240 -1.072:2.360))
    shape = dbCreateRect(cv list("M1" "drawing") list(-1.320:1.320 -1.072:1.440))
    shape = dbCreateRect(cv list("CB" "drawing") list(-1.268:1.740 -1.228:1.780))
    shape = dbCreateRect(cv list("CB" "drawing") list(-1.164:1.900 -1.124:1.940))
    shape = dbCreateRect(cv list("CA" "drawing") list(-1.315:2.100 -1.285:2.160))
    shape = dbCreateRect(cv list("M1" "drawing") list(-1.320:2.180 -1.280:2.240))
    shape = dbCreateRect(cv list("CA" "drawing") list(-1.315:1.620 -1.285:1.680))
    shape = dbCreateRect(cv list("CA" "drawing") list(-1.211:2.000 -1.181:2.060))
    shape = dbCreateRect(cv list("CA" "drawing") list(-1.107:2.100 -1.077:2.160))
    shape = dbCreateRect(cv list("M1" "drawing") list(-1.112:2.180 -1.072:2.240))
    shape = dbCreateRect(cv list("CA" "drawing") list(-1.107:1.520 -1.077:1.580))
    shape = dbCreateRect(cv list("M1" "drawing") list(-1.112:1.440 -1.072:1.500))
    shape = dbCreateRect(cv list("CT" "drawing") list(-1.092:1.808 -0.988:1.872))
    shape = dbCreateRect(cv list("RVTP" "drawing") list(-1.242:1.840 -0.838:2.482))
    shape = dbCreateRect(cv list("NW" "drawing") list(-1.242:1.840 -0.838:2.482))
    shape = dbCreateRect(cv list("PPLUS" "drawing") list(-1.242:1.840 -0.838:2.482))
    shape = dbCreateRect(cv list("RX" "drawing") list(-1.142:1.980 -0.938:2.180))
    shape = dbCreateRect(cv list("PC" "drawing") list(-1.050:1.840 -1.030:2.382))
    shape = dbCreateRect(cv list("CT" "drawing") list(-1.092:1.808 -0.988:1.872))
    shape = dbCreateRect(cv list("LVTN" "drawing") list(-1.242:1.198 -0.838:1.840))
    shape = dbCreateRect(cv list("NW" "drawing") list(-1.242:1.198 -0.838:1.840))
    shape = dbCreateRect(cv list("NPLUS" "drawing") list(-1.242:1.198 -0.838:1.840))
    shape = dbCreateRect(cv list("RX" "drawing") list(-1.142:1.500 -0.938:1.700))
    shape = dbCreateRect(cv list("PC" "drawing") list(-1.050:1.298 -1.030:1.840))
    shape = dbCreateRect(cv list("M1" "drawing") list(-1.112:2.240 -0.968:2.360))
    shape = dbCreateRect(cv list("M1" "drawing") list(-1.112:1.320 -0.968:1.440))
    shape = dbCreateRect(cv list("CB" "drawing") list(-1.060:2.280 -1.020:2.320))
    shape = dbCreateRect(cv list("CB" "drawing") list(-1.060:1.360 -1.020:1.400))
    shape = dbCreateRect(cv list("M1" "drawing") list(-0.904:1.600 -0.864:1.700))
    shape = dbCreateRect(cv list("M1" "drawing") list(-0.904:1.980 -0.864:2.080))
    shape = dbCreateRect(cv list("M1" "drawing") list(-1.008:1.500 -0.968:1.600))
    shape = dbCreateRect(cv list("M1" "drawing") list(-1.008:2.080 -0.968:2.180))
    shape = dbCreateRect(cv list("M1" "drawing") list(-0.946:1.820 -0.926:1.860))
    shape = dbCreatePolygon(cv list("M1" "drawing") list(-0.884:1.980 -0.852:1.980 -0.852:1.700 -0.884:1.700 -0.884:1.660 -0.812:1.660 -0.812:2.020 -0.884:2.020))
    shape = dbCreateRect(cv list("CT" "drawing") list(-0.988:2.268 -0.884:2.332))
    shape = dbCreateRect(cv list("RVTP" "drawing") list(-1.138:1.840 -0.734:2.482))
    shape = dbCreateRect(cv list("NW" "drawing") list(-1.138:1.840 -0.734:2.482))
    shape = dbCreateRect(cv list("PPLUS" "drawing") list(-1.138:1.840 -0.734:2.482))
    shape = dbCreateRect(cv list("RX" "drawing") list(-1.038:1.980 -0.834:2.180))
    shape = dbCreateRect(cv list("PC" "drawing") list(-0.946:1.840 -0.926:2.382))
    shape = dbCreateRect(cv list("CT" "drawing") list(-0.988:1.348 -0.884:1.412))
    shape = dbCreateRect(cv list("LVTN" "drawing") list(-1.138:1.198 -0.734:1.840))
    shape = dbCreateRect(cv list("NW" "drawing") list(-1.138:1.198 -0.734:1.840))
    shape = dbCreateRect(cv list("NPLUS" "drawing") list(-1.138:1.198 -0.734:1.840))
    shape = dbCreateRect(cv list("RX" "drawing") list(-1.038:1.500 -0.834:1.700))
    shape = dbCreateRect(cv list("PC" "drawing") list(-0.946:1.298 -0.926:1.840))
    shape = dbCreateRect(cv list("M1" "drawing") list(-1.008:2.240 -0.864:2.360))
    shape = dbCreateRect(cv list("M1" "drawing") list(-1.008:1.320 -0.864:1.440))
    shape = dbCreateRect(cv list("CB" "drawing") list(-0.956:1.820 -0.916:1.860))
    shape = dbCreateRect(cv list("CA" "drawing") list(-1.003:2.100 -0.973:2.160))
    shape = dbCreateRect(cv list("M1" "drawing") list(-1.008:2.180 -0.968:2.240))
    shape = dbCreateRect(cv list("CA" "drawing") list(-1.003:1.520 -0.973:1.580))
    shape = dbCreateRect(cv list("M1" "drawing") list(-1.008:1.440 -0.968:1.500))
    shape = dbCreateRect(cv list("CA" "drawing") list(-0.899:2.000 -0.869:2.060))
    shape = dbCreateRect(cv list("CA" "drawing") list(-0.899:1.620 -0.869:1.680))
    shape = dbCreateRect(cv list("M1" "drawing") list(-1.040:1.820 -0.892:1.860))
    shape = dbCreateRect(cv list("CB" "drawing") list(-1.372:1.360 -1.332:1.400))
    shape = dbCreateRect(cv list("CB" "drawing") list(-1.372:2.280 -1.332:2.320))
    shape = dbCreateRect(cv list("M1" "drawing") list(-1.424:1.320 -1.280:1.440))
    shape = dbCreateRect(cv list("M1" "drawing") list(-1.424:2.240 -1.280:2.360))
    shape = dbCreateRect(cv list("PC" "drawing") list(-1.362:1.298 -1.342:1.840))
    shape = dbCreateRect(cv list("RX" "drawing") list(-1.454:1.500 -1.250:1.700))
    shape = dbCreateRect(cv list("NPLUS" "drawing") list(-1.554:1.198 -1.150:1.840))
    shape = dbCreateRect(cv list("NW" "drawing") list(-1.554:1.198 -1.150:1.840))
    shape = dbCreateRect(cv list("LVTN" "drawing") list(-1.554:1.198 -1.150:1.840))
    shape = dbCreateRect(cv list("CT" "drawing") list(-1.404:1.808 -1.300:1.872))
    shape = dbCreateRect(cv list("PC" "drawing") list(-1.362:1.840 -1.342:2.382))
    shape = dbCreateRect(cv list("RX" "drawing") list(-1.454:1.980 -1.250:2.180))
    shape = dbCreateRect(cv list("PPLUS" "drawing") list(-1.554:1.840 -1.150:2.482))
    shape = dbCreateRect(cv list("NW" "drawing") list(-1.554:1.840 -1.150:2.482))
    shape = dbCreateRect(cv list("RVTP" "drawing") list(-1.554:1.840 -1.150:2.482))
    shape = dbCreateRect(cv list("CT" "drawing") list(-1.404:1.808 -1.300:1.872))
    shape = dbCreateRect(cv list("M1" "drawing") list(-1.632:1.500 -1.592:1.600))
    shape = dbCreateRect(cv list("M1" "drawing") list(-1.632:2.080 -1.592:2.180))
    shape = dbCreateRect(cv list("M1" "drawing") list(-1.736:1.600 -1.696:1.700))
    shape = dbCreateRect(cv list("M1" "drawing") list(-1.840:1.500 -1.800:1.600))
    shape = dbCreateRect(cv list("M1" "drawing") list(-1.840:1.980 -1.800:2.080))
    shape = dbCreateRect(cv list("M1" "drawing") list(-1.674:1.900 -1.654:1.940))
    shape = dbCreateRect(cv list("M1" "drawing") list(-1.778:1.740 -1.758:1.780))
    shape = dbCreatePolygon(cv list("M1" "drawing") list(-1.820:1.980 -1.580:1.980 -1.580:1.700 -1.716:1.700 -1.716:1.660 -1.540:1.660 -1.540:2.020 -1.820:2.020))
    shape = dbCreateRect(cv list("M1" "drawing") list(-1.812:1.740 -1.620:1.780))
    shape = dbCreateRect(cv list("M1" "drawing") list(-1.812:1.900 -1.620:1.940))
    shape = dbCreateRect(cv list("CT" "drawing") list(-1.820:2.268 -1.612:2.332))
    shape = dbCreateRect(cv list("RVTP" "drawing") list(-1.970:1.840 -1.462:2.482))
    shape = dbCreateRect(cv list("NW" "drawing") list(-1.970:1.840 -1.462:2.482))
    shape = dbCreateRect(cv list("PPLUS" "drawing") list(-1.970:1.840 -1.462:2.482))
    shape = dbCreateRect(cv list("RX" "drawing") list(-1.870:1.980 -1.562:2.180))
    shape = dbCreateRect(cv list("PC" "drawing") list(-1.778:1.840 -1.758:2.382))
    shape = dbCreateRect(cv list("PC" "drawing") list(-1.674:1.840 -1.654:2.382))
    shape = dbCreateRect(cv list("CT" "drawing") list(-1.820:1.348 -1.612:1.412))
    shape = dbCreateRect(cv list("LVTN" "drawing") list(-1.970:1.198 -1.462:1.840))
    shape = dbCreateRect(cv list("NW" "drawing") list(-1.970:1.198 -1.462:1.840))
    shape = dbCreateRect(cv list("NPLUS" "drawing") list(-1.970:1.198 -1.462:1.840))
    shape = dbCreateRect(cv list("RX" "drawing") list(-1.870:1.500 -1.562:1.700))
    shape = dbCreateRect(cv list("PC" "drawing") list(-1.778:1.298 -1.758:1.840))
    shape = dbCreateRect(cv list("PC" "drawing") list(-1.674:1.298 -1.654:1.840))
    shape = dbCreateRect(cv list("M1" "drawing") list(-1.840:2.240 -1.592:2.360))
    shape = dbCreateRect(cv list("M1" "drawing") list(-1.840:1.320 -1.592:1.440))
    shape = dbCreateRect(cv list("CB" "drawing") list(-1.788:1.740 -1.748:1.780))
    shape = dbCreateRect(cv list("CB" "drawing") list(-1.684:1.900 -1.644:1.940))
    shape = dbCreateRect(cv list("CA" "drawing") list(-1.835:2.000 -1.805:2.060))
    shape = dbCreateRect(cv list("CA" "drawing") list(-1.835:1.520 -1.805:1.580))
    shape = dbCreateRect(cv list("M1" "drawing") list(-1.840:1.440 -1.800:1.500))
    shape = dbCreateRect(cv list("CA" "drawing") list(-1.731:1.620 -1.701:1.680))
    shape = dbCreateRect(cv list("CA" "drawing") list(-1.627:2.100 -1.597:2.160))
    shape = dbCreateRect(cv list("M1" "drawing") list(-1.632:2.180 -1.592:2.240))
    shape = dbCreateRect(cv list("CA" "drawing") list(-1.627:1.520 -1.597:1.580))
    shape = dbCreateRect(cv list("M1" "drawing") list(-1.632:1.440 -1.592:1.500))
    shape = dbCreateRect(cv list("CT" "drawing") list(-1.612:1.808 -1.508:1.872))
    shape = dbCreateRect(cv list("RVTP" "drawing") list(-1.762:1.840 -1.358:2.482))
    shape = dbCreateRect(cv list("NW" "drawing") list(-1.762:1.840 -1.358:2.482))
    shape = dbCreateRect(cv list("PPLUS" "drawing") list(-1.762:1.840 -1.358:2.482))
    shape = dbCreateRect(cv list("RX" "drawing") list(-1.662:1.980 -1.458:2.180))
    shape = dbCreateRect(cv list("PC" "drawing") list(-1.570:1.840 -1.550:2.382))
    shape = dbCreateRect(cv list("CT" "drawing") list(-1.612:1.808 -1.508:1.872))
    shape = dbCreateRect(cv list("LVTN" "drawing") list(-1.762:1.198 -1.358:1.840))
    shape = dbCreateRect(cv list("NW" "drawing") list(-1.762:1.198 -1.358:1.840))
    shape = dbCreateRect(cv list("NPLUS" "drawing") list(-1.762:1.198 -1.358:1.840))
    shape = dbCreateRect(cv list("RX" "drawing") list(-1.662:1.500 -1.458:1.700))
    shape = dbCreateRect(cv list("PC" "drawing") list(-1.570:1.298 -1.550:1.840))
    shape = dbCreateRect(cv list("M1" "drawing") list(-1.632:2.240 -1.488:2.360))
    shape = dbCreateRect(cv list("M1" "drawing") list(-1.632:1.320 -1.488:1.440))
    shape = dbCreateRect(cv list("CB" "drawing") list(-1.580:2.280 -1.540:2.320))
    shape = dbCreateRect(cv list("CB" "drawing") list(-1.580:1.360 -1.540:1.400))
    shape = dbCreateRect(cv list("M1" "drawing") list(-1.424:1.600 -1.384:1.700))
    shape = dbCreateRect(cv list("M1" "drawing") list(-1.424:1.980 -1.384:2.080))
    shape = dbCreateRect(cv list("M1" "drawing") list(-1.528:1.500 -1.488:1.600))
    shape = dbCreateRect(cv list("M1" "drawing") list(-1.528:2.080 -1.488:2.180))
    shape = dbCreateRect(cv list("M1" "drawing") list(-1.466:1.820 -1.446:1.860))
    shape = dbCreatePolygon(cv list("M1" "drawing") list(-1.404:1.980 -1.372:1.980 -1.372:1.700 -1.404:1.700 -1.404:1.660 -1.332:1.660 -1.332:2.020 -1.404:2.020))
    shape = dbCreateRect(cv list("CT" "drawing") list(-1.508:2.268 -1.404:2.332))
    shape = dbCreateRect(cv list("RVTP" "drawing") list(-1.658:1.840 -1.254:2.482))
    shape = dbCreateRect(cv list("NW" "drawing") list(-1.658:1.840 -1.254:2.482))
    shape = dbCreateRect(cv list("PPLUS" "drawing") list(-1.658:1.840 -1.254:2.482))
    shape = dbCreateRect(cv list("RX" "drawing") list(-1.558:1.980 -1.354:2.180))
    shape = dbCreateRect(cv list("PC" "drawing") list(-1.466:1.840 -1.446:2.382))
    shape = dbCreateRect(cv list("CT" "drawing") list(-1.508:1.348 -1.404:1.412))
    shape = dbCreateRect(cv list("LVTN" "drawing") list(-1.658:1.198 -1.254:1.840))
    shape = dbCreateRect(cv list("NW" "drawing") list(-1.658:1.198 -1.254:1.840))
    shape = dbCreateRect(cv list("NPLUS" "drawing") list(-1.658:1.198 -1.254:1.840))
    shape = dbCreateRect(cv list("RX" "drawing") list(-1.558:1.500 -1.354:1.700))
    shape = dbCreateRect(cv list("PC" "drawing") list(-1.466:1.298 -1.446:1.840))
    shape = dbCreateRect(cv list("M1" "drawing") list(-1.528:2.240 -1.384:2.360))
    shape = dbCreateRect(cv list("M1" "drawing") list(-1.528:1.320 -1.384:1.440))
    shape = dbCreateRect(cv list("CB" "drawing") list(-1.476:1.820 -1.436:1.860))
    shape = dbCreateRect(cv list("CA" "drawing") list(-1.523:2.100 -1.493:2.160))
    shape = dbCreateRect(cv list("M1" "drawing") list(-1.528:2.180 -1.488:2.240))
    shape = dbCreateRect(cv list("CA" "drawing") list(-1.523:1.520 -1.493:1.580))
    shape = dbCreateRect(cv list("M1" "drawing") list(-1.528:1.440 -1.488:1.500))
    shape = dbCreateRect(cv list("CA" "drawing") list(-1.419:2.000 -1.389:2.060))
    shape = dbCreateRect(cv list("CA" "drawing") list(-1.419:1.620 -1.389:1.680))
    shape = dbCreateRect(cv list("M1" "drawing") list(-1.560:1.820 -1.412:1.860))
    shape = dbCreateRect(cv list("CT" "drawing") list(-1.924:1.808 -1.820:1.872))
    shape = dbCreateRect(cv list("RVTP" "drawing") list(-2.074:1.840 -1.670:2.482))
    shape = dbCreateRect(cv list("NW" "drawing") list(-2.074:1.840 -1.670:2.482))
    shape = dbCreateRect(cv list("PPLUS" "drawing") list(-2.074:1.840 -1.670:2.482))
    shape = dbCreateRect(cv list("RX" "drawing") list(-1.974:1.980 -1.770:2.180))
    shape = dbCreateRect(cv list("PC" "drawing") list(-1.882:1.840 -1.862:2.382))
    shape = dbCreateRect(cv list("CT" "drawing") list(-1.924:1.808 -1.820:1.872))
    shape = dbCreateRect(cv list("LVTN" "drawing") list(-2.074:1.198 -1.670:1.840))
    shape = dbCreateRect(cv list("NW" "drawing") list(-2.074:1.198 -1.670:1.840))
    shape = dbCreateRect(cv list("NPLUS" "drawing") list(-2.074:1.198 -1.670:1.840))
    shape = dbCreateRect(cv list("RX" "drawing") list(-1.974:1.500 -1.770:1.700))
    shape = dbCreateRect(cv list("PC" "drawing") list(-1.882:1.298 -1.862:1.840))
    shape = dbCreateRect(cv list("M1" "drawing") list(-1.944:2.240 -1.800:2.360))
    shape = dbCreateRect(cv list("M1" "drawing") list(-1.944:1.320 -1.800:1.440))
    shape = dbCreateRect(cv list("CB" "drawing") list(-1.892:2.280 -1.852:2.320))
    shape = dbCreateRect(cv list("CB" "drawing") list(-1.892:1.360 -1.852:1.400))
    shape = dbCreateRect(cv list("M1" "drawing") list(-1.944:1.600 -1.904:1.700))
    shape = dbCreateRect(cv list("M1" "drawing") list(-1.944:1.980 -1.904:2.080))
    shape = dbCreateRect(cv list("M1" "drawing") list(-2.048:1.500 -2.008:1.600))
    shape = dbCreateRect(cv list("M1" "drawing") list(-2.048:2.080 -2.008:2.180))
    shape = dbCreateRect(cv list("M1" "drawing") list(-1.986:1.820 -1.966:1.860))
    shape = dbCreatePolygon(cv list("M1" "drawing") list(-1.944:2.000 -1.944:1.680 -1.904:1.680 -1.904:2.000))
    shape = dbCreateRect(cv list("CT" "drawing") list(-2.028:2.268 -1.924:2.332))
    shape = dbCreateRect(cv list("RVTP" "drawing") list(-2.178:1.840 -1.774:2.482))
    shape = dbCreateRect(cv list("NW" "drawing") list(-2.178:1.840 -1.774:2.482))
    shape = dbCreateRect(cv list("PPLUS" "drawing") list(-2.178:1.840 -1.774:2.482))
    shape = dbCreateRect(cv list("RX" "drawing") list(-2.078:1.980 -1.874:2.180))
    shape = dbCreateRect(cv list("PC" "drawing") list(-1.986:1.840 -1.966:2.382))
    shape = dbCreateRect(cv list("CT" "drawing") list(-2.028:1.348 -1.924:1.412))
    shape = dbCreateRect(cv list("LVTN" "drawing") list(-2.178:1.198 -1.774:1.840))
    shape = dbCreateRect(cv list("NW" "drawing") list(-2.178:1.198 -1.774:1.840))
    shape = dbCreateRect(cv list("NPLUS" "drawing") list(-2.178:1.198 -1.774:1.840))
    shape = dbCreateRect(cv list("RX" "drawing") list(-2.078:1.500 -1.874:1.700))
    shape = dbCreateRect(cv list("PC" "drawing") list(-1.986:1.298 -1.966:1.840))
    shape = dbCreateRect(cv list("M1" "drawing") list(-2.048:2.240 -1.904:2.360))
    shape = dbCreateRect(cv list("M1" "drawing") list(-2.048:1.320 -1.904:1.440))
    shape = dbCreateRect(cv list("CB" "drawing") list(-1.996:1.820 -1.956:1.860))
    shape = dbCreateRect(cv list("CA" "drawing") list(-2.043:2.100 -2.013:2.160))
    shape = dbCreateRect(cv list("M1" "drawing") list(-2.048:2.180 -2.008:2.240))
    shape = dbCreateRect(cv list("CA" "drawing") list(-2.043:1.520 -2.013:1.580))
    shape = dbCreateRect(cv list("M1" "drawing") list(-2.048:1.440 -2.008:1.500))
    shape = dbCreateRect(cv list("CA" "drawing") list(-1.939:2.000 -1.909:2.060))
    shape = dbCreateRect(cv list("CA" "drawing") list(-1.939:1.620 -1.909:1.680))
    shape = dbCreateRect(cv list("CT" "drawing") list(-2.132:1.808 -2.028:1.872))
    shape = dbCreateRect(cv list("RVTP" "drawing") list(-2.282:1.840 -1.878:2.482))
    shape = dbCreateRect(cv list("NW" "drawing") list(-2.282:1.840 -1.878:2.482))
    shape = dbCreateRect(cv list("PPLUS" "drawing") list(-2.282:1.840 -1.878:2.482))
    shape = dbCreateRect(cv list("RX" "drawing") list(-2.182:1.980 -1.978:2.180))
    shape = dbCreateRect(cv list("PC" "drawing") list(-2.090:1.840 -2.070:2.382))
    shape = dbCreateRect(cv list("CT" "drawing") list(-2.132:1.808 -2.028:1.872))
    shape = dbCreateRect(cv list("LVTN" "drawing") list(-2.282:1.198 -1.878:1.840))
    shape = dbCreateRect(cv list("NW" "drawing") list(-2.282:1.198 -1.878:1.840))
    shape = dbCreateRect(cv list("NPLUS" "drawing") list(-2.282:1.198 -1.878:1.840))
    shape = dbCreateRect(cv list("RX" "drawing") list(-2.182:1.500 -1.978:1.700))
    shape = dbCreateRect(cv list("PC" "drawing") list(-2.090:1.298 -2.070:1.840))
    shape = dbCreateRect(cv list("M1" "drawing") list(-2.152:2.240 -2.008:2.360))
    shape = dbCreateRect(cv list("M1" "drawing") list(-2.152:1.320 -2.008:1.440))
    shape = dbCreateRect(cv list("CB" "drawing") list(-2.100:2.280 -2.060:2.320))
    shape = dbCreateRect(cv list("CB" "drawing") list(-2.100:1.360 -2.060:1.400))
    shape = dbCreateRect(cv list("M1" "drawing") list(-2.152:1.600 -2.112:1.700))
    shape = dbCreateRect(cv list("M1" "drawing") list(-2.152:1.980 -2.112:2.080))
    shape = dbCreateRect(cv list("M1" "drawing") list(-2.256:1.500 -2.216:1.600))
    shape = dbCreateRect(cv list("M1" "drawing") list(-2.256:2.080 -2.216:2.180))
    shape = dbCreateRect(cv list("M1" "drawing") list(-2.194:1.820 -2.174:1.860))
    shape = dbCreatePolygon(cv list("M1" "drawing") list(-2.152:2.000 -2.152:1.680 -2.112:1.680 -2.112:2.000))
    shape = dbCreateRect(cv list("CT" "drawing") list(-2.236:2.268 -2.132:2.332))
    shape = dbCreateRect(cv list("RVTP" "drawing") list(-2.386:1.840 -1.982:2.482))
    shape = dbCreateRect(cv list("NW" "drawing") list(-2.386:1.840 -1.982:2.482))
    shape = dbCreateRect(cv list("PPLUS" "drawing") list(-2.386:1.840 -1.982:2.482))
    shape = dbCreateRect(cv list("RX" "drawing") list(-2.286:1.980 -2.082:2.180))
    shape = dbCreateRect(cv list("PC" "drawing") list(-2.194:1.840 -2.174:2.382))
    shape = dbCreateRect(cv list("CT" "drawing") list(-2.236:1.348 -2.132:1.412))
    shape = dbCreateRect(cv list("LVTN" "drawing") list(-2.386:1.198 -1.982:1.840))
    shape = dbCreateRect(cv list("NW" "drawing") list(-2.386:1.198 -1.982:1.840))
    shape = dbCreateRect(cv list("NPLUS" "drawing") list(-2.386:1.198 -1.982:1.840))
    shape = dbCreateRect(cv list("RX" "drawing") list(-2.286:1.500 -2.082:1.700))
    shape = dbCreateRect(cv list("PC" "drawing") list(-2.194:1.298 -2.174:1.840))
    shape = dbCreateRect(cv list("M1" "drawing") list(-2.256:2.240 -2.112:2.360))
    shape = dbCreateRect(cv list("M1" "drawing") list(-2.256:1.320 -2.112:1.440))
    shape = dbCreateRect(cv list("CB" "drawing") list(-2.204:1.820 -2.164:1.860))
    shape = dbCreateRect(cv list("CA" "drawing") list(-2.251:2.100 -2.221:2.160))
    shape = dbCreateRect(cv list("M1" "drawing") list(-2.256:2.180 -2.216:2.240))
    shape = dbCreateRect(cv list("CA" "drawing") list(-2.251:1.520 -2.221:1.580))
    shape = dbCreateRect(cv list("M1" "drawing") list(-2.256:1.440 -2.216:1.500))
    shape = dbCreateRect(cv list("CA" "drawing") list(-2.147:2.000 -2.117:2.060))
    shape = dbCreateRect(cv list("CA" "drawing") list(-2.147:1.620 -2.117:1.680))
    shape = dbCreateRect(cv list("CT" "drawing") list(-2.652:-0.032 -2.548:0.032))
    shape = dbCreateRect(cv list("RVTP" "drawing") list(-2.802:0.000 -2.398:0.642))
    shape = dbCreateRect(cv list("NW" "drawing") list(-2.802:0.000 -2.398:0.642))
    shape = dbCreateRect(cv list("PPLUS" "drawing") list(-2.802:0.000 -2.398:0.642))
    shape = dbCreateRect(cv list("RX" "drawing") list(-2.702:0.140 -2.498:0.340))
    shape = dbCreateRect(cv list("PC" "drawing") list(-2.610:0.000 -2.590:0.542))
    shape = dbCreateRect(cv list("CT" "drawing") list(-2.652:-0.032 -2.548:0.032))
    shape = dbCreateRect(cv list("LVTN" "drawing") list(-2.802:-0.642 -2.398:0.000))
    shape = dbCreateRect(cv list("NW" "drawing") list(-2.802:-0.642 -2.398:0.000))
    shape = dbCreateRect(cv list("NPLUS" "drawing") list(-2.802:-0.642 -2.398:0.000))
    shape = dbCreateRect(cv list("RX" "drawing") list(-2.702:-0.340 -2.498:-0.140))
    shape = dbCreateRect(cv list("PC" "drawing") list(-2.610:-0.542 -2.590:0.000))
    shape = dbCreateRect(cv list("M1" "drawing") list(-2.672:0.400 -2.528:0.520))
    shape = dbCreateRect(cv list("M1" "drawing") list(-2.672:-0.520 -2.528:-0.400))
    shape = dbCreateRect(cv list("CB" "drawing") list(-2.620:0.440 -2.580:0.480))
    shape = dbCreateRect(cv list("CB" "drawing") list(-2.620:-0.480 -2.580:-0.440))
    shape = dbCreateRect(cv list("CT" "drawing") list(-2.756:-0.032 -2.652:0.032))
    shape = dbCreateRect(cv list("RVTP" "drawing") list(-2.906:0.000 -2.502:0.642))
    shape = dbCreateRect(cv list("NW" "drawing") list(-2.906:0.000 -2.502:0.642))
    shape = dbCreateRect(cv list("PPLUS" "drawing") list(-2.906:0.000 -2.502:0.642))
    shape = dbCreateRect(cv list("RX" "drawing") list(-2.806:0.140 -2.602:0.340))
    shape = dbCreateRect(cv list("PC" "drawing") list(-2.714:0.000 -2.694:0.542))
    shape = dbCreateRect(cv list("CT" "drawing") list(-2.756:-0.032 -2.652:0.032))
    shape = dbCreateRect(cv list("LVTN" "drawing") list(-2.906:-0.642 -2.502:0.000))
    shape = dbCreateRect(cv list("NW" "drawing") list(-2.906:-0.642 -2.502:0.000))
    shape = dbCreateRect(cv list("NPLUS" "drawing") list(-2.906:-0.642 -2.502:0.000))
    shape = dbCreateRect(cv list("RX" "drawing") list(-2.806:-0.340 -2.602:-0.140))
    shape = dbCreateRect(cv list("PC" "drawing") list(-2.714:-0.542 -2.694:0.000))
    shape = dbCreateRect(cv list("M1" "drawing") list(-2.776:0.400 -2.632:0.520))
    shape = dbCreateRect(cv list("M1" "drawing") list(-2.776:-0.520 -2.632:-0.400))
    shape = dbCreateRect(cv list("CB" "drawing") list(-2.724:0.440 -2.684:0.480))
    shape = dbCreateRect(cv list("CB" "drawing") list(-2.724:-0.480 -2.684:-0.440))
    shape = dbCreateRect(cv list("CT" "drawing") list(-2.860:-0.032 -2.756:0.032))
    shape = dbCreateRect(cv list("RVTP" "drawing") list(-3.010:0.000 -2.606:0.642))
    shape = dbCreateRect(cv list("NW" "drawing") list(-3.010:0.000 -2.606:0.642))
    shape = dbCreateRect(cv list("PPLUS" "drawing") list(-3.010:0.000 -2.606:0.642))
    shape = dbCreateRect(cv list("RX" "drawing") list(-2.910:0.140 -2.706:0.340))
    shape = dbCreateRect(cv list("PC" "drawing") list(-2.818:0.000 -2.798:0.542))
    shape = dbCreateRect(cv list("CT" "drawing") list(-2.860:-0.032 -2.756:0.032))
    shape = dbCreateRect(cv list("LVTN" "drawing") list(-3.010:-0.642 -2.606:0.000))
    shape = dbCreateRect(cv list("NW" "drawing") list(-3.010:-0.642 -2.606:0.000))
    shape = dbCreateRect(cv list("NPLUS" "drawing") list(-3.010:-0.642 -2.606:0.000))
    shape = dbCreateRect(cv list("RX" "drawing") list(-2.910:-0.340 -2.706:-0.140))
    shape = dbCreateRect(cv list("PC" "drawing") list(-2.818:-0.542 -2.798:0.000))
    shape = dbCreateRect(cv list("M1" "drawing") list(-2.880:0.400 -2.736:0.520))
    shape = dbCreateRect(cv list("M1" "drawing") list(-2.880:-0.520 -2.736:-0.400))
    shape = dbCreateRect(cv list("CB" "drawing") list(-2.828:0.440 -2.788:0.480))
    shape = dbCreateRect(cv list("CB" "drawing") list(-2.828:-0.480 -2.788:-0.440))
    shape = dbCreateRect(cv list("CT" "drawing") list(-2.964:-0.032 -2.860:0.032))
    shape = dbCreateRect(cv list("RVTP" "drawing") list(-3.114:0.000 -2.710:0.642))
    shape = dbCreateRect(cv list("NW" "drawing") list(-3.114:0.000 -2.710:0.642))
    shape = dbCreateRect(cv list("PPLUS" "drawing") list(-3.114:0.000 -2.710:0.642))
    shape = dbCreateRect(cv list("RX" "drawing") list(-3.014:0.140 -2.810:0.340))
    shape = dbCreateRect(cv list("PC" "drawing") list(-2.922:0.000 -2.902:0.542))
    shape = dbCreateRect(cv list("CT" "drawing") list(-2.964:-0.032 -2.860:0.032))
    shape = dbCreateRect(cv list("LVTN" "drawing") list(-3.114:-0.642 -2.710:0.000))
    shape = dbCreateRect(cv list("NW" "drawing") list(-3.114:-0.642 -2.710:0.000))
    shape = dbCreateRect(cv list("NPLUS" "drawing") list(-3.114:-0.642 -2.710:0.000))
    shape = dbCreateRect(cv list("RX" "drawing") list(-3.014:-0.340 -2.810:-0.140))
    shape = dbCreateRect(cv list("PC" "drawing") list(-2.922:-0.542 -2.902:0.000))
    shape = dbCreateRect(cv list("M1" "drawing") list(-2.984:0.400 -2.840:0.520))
    shape = dbCreateRect(cv list("M1" "drawing") list(-2.984:-0.520 -2.840:-0.400))
    shape = dbCreateRect(cv list("CB" "drawing") list(-2.932:0.440 -2.892:0.480))
    shape = dbCreateRect(cv list("CB" "drawing") list(-2.932:-0.480 -2.892:-0.440))
    shape = dbCreateRect(cv list("CT" "drawing") list(-2.964:0.952 -2.860:0.888))
    shape = dbCreateRect(cv list("RVTP" "drawing") list(-3.114:0.920 -2.710:0.278))
    shape = dbCreateRect(cv list("NW" "drawing") list(-3.114:0.920 -2.710:0.278))
    shape = dbCreateRect(cv list("PPLUS" "drawing") list(-3.114:0.920 -2.710:0.278))
    shape = dbCreateRect(cv list("RX" "drawing") list(-3.014:0.780 -2.810:0.580))
    shape = dbCreateRect(cv list("PC" "drawing") list(-2.922:0.920 -2.902:0.378))
    shape = dbCreateRect(cv list("CT" "drawing") list(-2.964:0.952 -2.860:0.888))
    shape = dbCreateRect(cv list("LVTN" "drawing") list(-3.114:1.562 -2.710:0.920))
    shape = dbCreateRect(cv list("NW" "drawing") list(-3.114:1.562 -2.710:0.920))
    shape = dbCreateRect(cv list("NPLUS" "drawing") list(-3.114:1.562 -2.710:0.920))
    shape = dbCreateRect(cv list("RX" "drawing") list(-3.014:1.260 -2.810:1.060))
    shape = dbCreateRect(cv list("PC" "drawing") list(-2.922:1.462 -2.902:0.920))
    shape = dbCreateRect(cv list("M1" "drawing") list(-2.984:0.520 -2.840:0.400))
    shape = dbCreateRect(cv list("M1" "drawing") list(-2.984:1.440 -2.840:1.320))
    shape = dbCreateRect(cv list("CB" "drawing") list(-2.932:0.480 -2.892:0.440))
    shape = dbCreateRect(cv list("CB" "drawing") list(-2.932:1.400 -2.892:1.360))
    shape = dbCreateRect(cv list("CT" "drawing") list(-2.340:1.808 -2.236:1.872))
    shape = dbCreateRect(cv list("RVTP" "drawing") list(-2.490:1.840 -2.086:2.482))
    shape = dbCreateRect(cv list("NW" "drawing") list(-2.490:1.840 -2.086:2.482))
    shape = dbCreateRect(cv list("PPLUS" "drawing") list(-2.490:1.840 -2.086:2.482))
    shape = dbCreateRect(cv list("RX" "drawing") list(-2.390:1.980 -2.186:2.180))
    shape = dbCreateRect(cv list("PC" "drawing") list(-2.298:1.840 -2.278:2.382))
    shape = dbCreateRect(cv list("CT" "drawing") list(-2.340:1.808 -2.236:1.872))
    shape = dbCreateRect(cv list("LVTN" "drawing") list(-2.490:1.198 -2.086:1.840))
    shape = dbCreateRect(cv list("NW" "drawing") list(-2.490:1.198 -2.086:1.840))
    shape = dbCreateRect(cv list("NPLUS" "drawing") list(-2.490:1.198 -2.086:1.840))
    shape = dbCreateRect(cv list("RX" "drawing") list(-2.390:1.500 -2.186:1.700))
    shape = dbCreateRect(cv list("PC" "drawing") list(-2.298:1.298 -2.278:1.840))
    shape = dbCreateRect(cv list("M1" "drawing") list(-2.360:2.240 -2.216:2.360))
    shape = dbCreateRect(cv list("M1" "drawing") list(-2.360:1.320 -2.216:1.440))
    shape = dbCreateRect(cv list("CB" "drawing") list(-2.308:2.280 -2.268:2.320))
    shape = dbCreateRect(cv list("CB" "drawing") list(-2.308:1.360 -2.268:1.400))
    shape = dbCreateRect(cv list("CT" "drawing") list(-2.444:1.808 -2.340:1.872))
    shape = dbCreateRect(cv list("RVTP" "drawing") list(-2.594:1.840 -2.190:2.482))
    shape = dbCreateRect(cv list("NW" "drawing") list(-2.594:1.840 -2.190:2.482))
    shape = dbCreateRect(cv list("PPLUS" "drawing") list(-2.594:1.840 -2.190:2.482))
    shape = dbCreateRect(cv list("RX" "drawing") list(-2.494:1.980 -2.290:2.180))
    shape = dbCreateRect(cv list("PC" "drawing") list(-2.402:1.840 -2.382:2.382))
    shape = dbCreateRect(cv list("CT" "drawing") list(-2.444:1.808 -2.340:1.872))
    shape = dbCreateRect(cv list("LVTN" "drawing") list(-2.594:1.198 -2.190:1.840))
    shape = dbCreateRect(cv list("NW" "drawing") list(-2.594:1.198 -2.190:1.840))
    shape = dbCreateRect(cv list("NPLUS" "drawing") list(-2.594:1.198 -2.190:1.840))
    shape = dbCreateRect(cv list("RX" "drawing") list(-2.494:1.500 -2.290:1.700))
    shape = dbCreateRect(cv list("PC" "drawing") list(-2.402:1.298 -2.382:1.840))
    shape = dbCreateRect(cv list("M1" "drawing") list(-2.464:2.240 -2.320:2.360))
    shape = dbCreateRect(cv list("M1" "drawing") list(-2.464:1.320 -2.320:1.440))
    shape = dbCreateRect(cv list("CB" "drawing") list(-2.412:2.280 -2.372:2.320))
    shape = dbCreateRect(cv list("CB" "drawing") list(-2.412:1.360 -2.372:1.400))
    shape = dbCreateRect(cv list("CT" "drawing") list(-2.548:1.808 -2.444:1.872))
    shape = dbCreateRect(cv list("RVTP" "drawing") list(-2.698:1.840 -2.294:2.482))
    shape = dbCreateRect(cv list("NW" "drawing") list(-2.698:1.840 -2.294:2.482))
    shape = dbCreateRect(cv list("PPLUS" "drawing") list(-2.698:1.840 -2.294:2.482))
    shape = dbCreateRect(cv list("RX" "drawing") list(-2.598:1.980 -2.394:2.180))
    shape = dbCreateRect(cv list("PC" "drawing") list(-2.506:1.840 -2.486:2.382))
    shape = dbCreateRect(cv list("CT" "drawing") list(-2.548:1.808 -2.444:1.872))
    shape = dbCreateRect(cv list("LVTN" "drawing") list(-2.698:1.198 -2.294:1.840))
    shape = dbCreateRect(cv list("NW" "drawing") list(-2.698:1.198 -2.294:1.840))
    shape = dbCreateRect(cv list("NPLUS" "drawing") list(-2.698:1.198 -2.294:1.840))
    shape = dbCreateRect(cv list("RX" "drawing") list(-2.598:1.500 -2.394:1.700))
    shape = dbCreateRect(cv list("PC" "drawing") list(-2.506:1.298 -2.486:1.840))
    shape = dbCreateRect(cv list("M1" "drawing") list(-2.568:2.240 -2.424:2.360))
    shape = dbCreateRect(cv list("M1" "drawing") list(-2.568:1.320 -2.424:1.440))
    shape = dbCreateRect(cv list("CB" "drawing") list(-2.516:2.280 -2.476:2.320))
    shape = dbCreateRect(cv list("CB" "drawing") list(-2.516:1.360 -2.476:1.400))
    shape = dbCreateRect(cv list("CT" "drawing") list(-2.652:1.808 -2.548:1.872))
    shape = dbCreateRect(cv list("RVTP" "drawing") list(-2.802:1.840 -2.398:2.482))
    shape = dbCreateRect(cv list("NW" "drawing") list(-2.802:1.840 -2.398:2.482))
    shape = dbCreateRect(cv list("PPLUS" "drawing") list(-2.802:1.840 -2.398:2.482))
    shape = dbCreateRect(cv list("RX" "drawing") list(-2.702:1.980 -2.498:2.180))
    shape = dbCreateRect(cv list("PC" "drawing") list(-2.610:1.840 -2.590:2.382))
    shape = dbCreateRect(cv list("CT" "drawing") list(-2.652:1.808 -2.548:1.872))
    shape = dbCreateRect(cv list("LVTN" "drawing") list(-2.802:1.198 -2.398:1.840))
    shape = dbCreateRect(cv list("NW" "drawing") list(-2.802:1.198 -2.398:1.840))
    shape = dbCreateRect(cv list("NPLUS" "drawing") list(-2.802:1.198 -2.398:1.840))
    shape = dbCreateRect(cv list("RX" "drawing") list(-2.702:1.500 -2.498:1.700))
    shape = dbCreateRect(cv list("PC" "drawing") list(-2.610:1.298 -2.590:1.840))
    shape = dbCreateRect(cv list("M1" "drawing") list(-2.672:2.240 -2.528:2.360))
    shape = dbCreateRect(cv list("M1" "drawing") list(-2.672:1.320 -2.528:1.440))
    shape = dbCreateRect(cv list("CB" "drawing") list(-2.620:2.280 -2.580:2.320))
    shape = dbCreateRect(cv list("CB" "drawing") list(-2.620:1.360 -2.580:1.400))
    shape = dbCreateRect(cv list("CT" "drawing") list(-2.756:1.808 -2.652:1.872))
    shape = dbCreateRect(cv list("RVTP" "drawing") list(-2.906:1.840 -2.502:2.482))
    shape = dbCreateRect(cv list("NW" "drawing") list(-2.906:1.840 -2.502:2.482))
    shape = dbCreateRect(cv list("PPLUS" "drawing") list(-2.906:1.840 -2.502:2.482))
    shape = dbCreateRect(cv list("RX" "drawing") list(-2.806:1.980 -2.602:2.180))
    shape = dbCreateRect(cv list("PC" "drawing") list(-2.714:1.840 -2.694:2.382))
    shape = dbCreateRect(cv list("CT" "drawing") list(-2.756:1.808 -2.652:1.872))
    shape = dbCreateRect(cv list("LVTN" "drawing") list(-2.906:1.198 -2.502:1.840))
    shape = dbCreateRect(cv list("NW" "drawing") list(-2.906:1.198 -2.502:1.840))
    shape = dbCreateRect(cv list("NPLUS" "drawing") list(-2.906:1.198 -2.502:1.840))
    shape = dbCreateRect(cv list("RX" "drawing") list(-2.806:1.500 -2.602:1.700))
    shape = dbCreateRect(cv list("PC" "drawing") list(-2.714:1.298 -2.694:1.840))
    shape = dbCreateRect(cv list("M1" "drawing") list(-2.776:2.240 -2.632:2.360))
    shape = dbCreateRect(cv list("M1" "drawing") list(-2.776:1.320 -2.632:1.440))
    shape = dbCreateRect(cv list("CB" "drawing") list(-2.724:2.280 -2.684:2.320))
    shape = dbCreateRect(cv list("CB" "drawing") list(-2.724:1.360 -2.684:1.400))
    shape = dbCreateRect(cv list("CT" "drawing") list(-2.860:1.808 -2.756:1.872))
    shape = dbCreateRect(cv list("RVTP" "drawing") list(-3.010:1.840 -2.606:2.482))
    shape = dbCreateRect(cv list("NW" "drawing") list(-3.010:1.840 -2.606:2.482))
    shape = dbCreateRect(cv list("PPLUS" "drawing") list(-3.010:1.840 -2.606:2.482))
    shape = dbCreateRect(cv list("RX" "drawing") list(-2.910:1.980 -2.706:2.180))
    shape = dbCreateRect(cv list("PC" "drawing") list(-2.818:1.840 -2.798:2.382))
    shape = dbCreateRect(cv list("CT" "drawing") list(-2.860:1.808 -2.756:1.872))
    shape = dbCreateRect(cv list("LVTN" "drawing") list(-3.010:1.198 -2.606:1.840))
    shape = dbCreateRect(cv list("NW" "drawing") list(-3.010:1.198 -2.606:1.840))
    shape = dbCreateRect(cv list("NPLUS" "drawing") list(-3.010:1.198 -2.606:1.840))
    shape = dbCreateRect(cv list("RX" "drawing") list(-2.910:1.500 -2.706:1.700))
    shape = dbCreateRect(cv list("PC" "drawing") list(-2.818:1.298 -2.798:1.840))
    shape = dbCreateRect(cv list("M1" "drawing") list(-2.880:2.240 -2.736:2.360))
    shape = dbCreateRect(cv list("M1" "drawing") list(-2.880:1.320 -2.736:1.440))
    shape = dbCreateRect(cv list("CB" "drawing") list(-2.828:2.280 -2.788:2.320))
    shape = dbCreateRect(cv list("CB" "drawing") list(-2.828:1.360 -2.788:1.400))
    shape = dbCreateRect(cv list("CT" "drawing") list(-2.964:1.808 -2.860:1.872))
    shape = dbCreateRect(cv list("RVTP" "drawing") list(-3.114:1.840 -2.710:2.482))
    shape = dbCreateRect(cv list("NW" "drawing") list(-3.114:1.840 -2.710:2.482))
    shape = dbCreateRect(cv list("PPLUS" "drawing") list(-3.114:1.840 -2.710:2.482))
    shape = dbCreateRect(cv list("RX" "drawing") list(-3.014:1.980 -2.810:2.180))
    shape = dbCreateRect(cv list("PC" "drawing") list(-2.922:1.840 -2.902:2.382))
    shape = dbCreateRect(cv list("CT" "drawing") list(-2.964:1.808 -2.860:1.872))
    shape = dbCreateRect(cv list("LVTN" "drawing") list(-3.114:1.198 -2.710:1.840))
    shape = dbCreateRect(cv list("NW" "drawing") list(-3.114:1.198 -2.710:1.840))
    shape = dbCreateRect(cv list("NPLUS" "drawing") list(-3.114:1.198 -2.710:1.840))
    shape = dbCreateRect(cv list("RX" "drawing") list(-3.014:1.500 -2.810:1.700))
    shape = dbCreateRect(cv list("PC" "drawing") list(-2.922:1.298 -2.902:1.840))
    shape = dbCreateRect(cv list("M1" "drawing") list(-2.984:2.240 -2.840:2.360))
    shape = dbCreateRect(cv list("M1" "drawing") list(-2.984:1.320 -2.840:1.440))
    shape = dbCreateRect(cv list("CB" "drawing") list(-2.932:2.280 -2.892:2.320))
    shape = dbCreateRect(cv list("CB" "drawing") list(-2.932:1.360 -2.892:1.400))
    shape = dbCreateRect(cv list("M1" "drawing") list(-0.020:0.000 0.020:0.080))
    shape = dbCreateRect(cv list("M1" "drawing") list(-0.020:0.840 0.020:0.920))
    shape = dbCreateRect(cv list("M1" "drawing") list(-0.020:1.840 0.020:1.920))
    shape = dbCreatePolygon(cv list("M1" "drawing") list())
    shape = dbCreatePolygon(cv list("M1" "drawing") list(-1.904:0.920 -1.904:0.980 -1.768:0.980 -1.768:1.020 -1.944:1.020 -1.944:0.920))
    shape = dbCreateLabel(cv list("M1" "label") 2.288:0.920 "BOUT" "centerCenter" "R0" "roman" 0.1)
    shape = dbCreateLabel(cv list("M1" "label") 1.092:-0.460 "VSS" "centerCenter" "R0" "roman" 0.1)
    shape = dbCreateLabel(cv list("M1" "label") 2.288:1.840 "DOUT" "centerCenter" "R0" "roman" 0.1)
    shape = dbCreateLabel(cv list("M1" "label") -1.664:0.080 "DIN" "centerCenter" "R0" "roman" 0.1)
    shape = dbCreateLabel(cv list("M1" "label") 1.092:2.300 "VDD" "centerCenter" "R0" "roman" 0.1)
    shape = dbCreateLabel(cv list("M1" "label") -2.808:1.000 "RST" "centerCenter" "R0" "roman" 0.1)
    shape = dbCreateLabel(cv list("M1" "label") -2.392:0.080 "UPD" "centerCenter" "R0" "roman" 0.1)
    shape = dbCreateLabel(cv list("M1" "label") -1.976:1.840 "CLK" "centerCenter" "R0" "roman" 0.1)
) ; let
